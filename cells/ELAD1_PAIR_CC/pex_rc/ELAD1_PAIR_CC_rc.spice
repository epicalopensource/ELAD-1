* SPICE3 file created from ELAD1_PAIR_CC_flat.ext - technology: sky130A

X0 D2.t5 VINM.t5 a_433_1469.t114 VGND.t0 sky130_fd_pr__nfet_01v8 ad=0.25 pd=1.5 as=0.25 ps=1.5 w=1 l=1
X1 VGND.t36 VGND.t34 VGND.t35 VGND.t2 sky130_fd_pr__nfet_01v8 ad=0.25 pd=1.5 as=0 ps=0 w=1 l=1
X2 VGND.t42 VGND.t40 VGND.t41 VGND.t8 sky130_fd_pr__nfet_01v8 ad=0.5 pd=3 as=0 ps=0 w=1 l=1
X3 a_433_1469.t30 a_433_1469.t28 a_433_1469.t29 VGND.t6 sky130_fd_pr__nfet_01v8 ad=0.25 pd=1.5 as=0 ps=0 w=1 l=1
X4 D1.t2 VINP.t7 a_433_1469.t8 VGND.t9 sky130_fd_pr__nfet_01v8 ad=0.25 pd=1.5 as=0.25 ps=1.5 w=1 l=1
X5 D1.t4 VINP.t3 a_433_1469.t12 VGND.t11 sky130_fd_pr__nfet_01v8 ad=0.25 pd=1.5 as=0.25 ps=1.5 w=1 l=1
X6 a_433_1469.t2 VBIAS.t21 VGND.t18 VGND.t0 sky130_fd_pr__nfet_01v8 ad=0.25 pd=1.5 as=0.25 ps=1.5 w=1 l=1
X7 a_433_1469.t45 a_433_1469.t43 a_433_1469.t44 VGND.t1 sky130_fd_pr__nfet_01v8 ad=0.25 pd=1.5 as=0 ps=0 w=1 l=1
X8 a_433_1469.t108 a_433_1469.t106 a_433_1469.t107 VGND.t2 sky130_fd_pr__nfet_01v8 ad=0.25 pd=1.5 as=0 ps=0 w=1 l=1
X9 a_433_1469.t66 a_433_1469.t64 a_433_1469.t65 VGND.t8 sky130_fd_pr__nfet_01v8 ad=0.5 pd=3 as=0 ps=0 w=1 l=1
X10 VGND.t39 VGND.t37 VGND.t38 VGND.t3 sky130_fd_pr__nfet_01v8 ad=0.25 pd=1.5 as=0 ps=0 w=1 l=1
X11 VGND.t45 VGND.t43 VGND.t44 VGND.t5 sky130_fd_pr__nfet_01v8 ad=0.25 pd=1.5 as=0 ps=0 w=1 l=1
X12 a_433_1469.t63 a_433_1469.t61 a_433_1469.t62 VGND.t3 sky130_fd_pr__nfet_01v8 ad=0.25 pd=1.5 as=0 ps=0 w=1 l=1
X13 D2.t6 VINM.t1 a_433_1469.t118 VGND.t6 sky130_fd_pr__nfet_01v8 ad=0.25 pd=1.5 as=0.25 ps=1.5 w=1 l=1
X14 a_433_1469.t39 a_433_1469.t37 a_433_1469.t38 VGND.t4 sky130_fd_pr__nfet_01v8 ad=0.25 pd=1.5 as=0 ps=0 w=1 l=1
X15 a_433_1469.t11 VINP.t4 D1.t7 VGND.t7 sky130_fd_pr__nfet_01v8 ad=0.25 pd=1.5 as=0.25 ps=1.5 w=1 l=1
X16 a_433_1469.t15 VINP.t0 D1.t1 VGND.t1 sky130_fd_pr__nfet_01v8 ad=0.25 pd=1.5 as=0.25 ps=1.5 w=1 l=1
X17 a_433_1469.t102 a_433_1469.t100 a_433_1469.t101 VGND.t0 sky130_fd_pr__nfet_01v8 ad=0.25 pd=1.5 as=0 ps=0 w=1 l=1
X18 a_433_1469.t84 a_433_1469.t82 a_433_1469.t83 VGND.t9 sky130_fd_pr__nfet_01v8 ad=0.25 pd=1.5 as=0 ps=0 w=1 l=1
X19 a_433_1469.t21 a_433_1469.t19 a_433_1469.t20 VGND.t5 sky130_fd_pr__nfet_01v8 ad=0.25 pd=1.5 as=0 ps=0 w=1 l=1
X20 a_433_1469.t4 VBIAS.t19 VGND.t13 VGND.t9 sky130_fd_pr__nfet_01v8 ad=0.25 pd=1.5 as=0.25 ps=1.5 w=1 l=1
X21 a_433_1469.t48 a_433_1469.t46 a_433_1469.t47 VGND.t2 sky130_fd_pr__nfet_01v8 ad=0.25 pd=1.5 as=0 ps=0 w=1 l=1
X22 a_433_1469.t9 VINP.t6 D1.t3 VGND.t10 sky130_fd_pr__nfet_01v8 ad=0.25 pd=1.5 as=0.25 ps=1.5 w=1 l=1
X23 a_433_1469.t13 VINP.t2 D1.t6 VGND.t4 sky130_fd_pr__nfet_01v8 ad=0.25 pd=1.5 as=0.25 ps=1.5 w=1 l=1
X24 a_433_1469.t111 a_433_1469.t109 a_433_1469.t110 VGND.t3 sky130_fd_pr__nfet_01v8 ad=0.25 pd=1.5 as=0 ps=0 w=1 l=1
X25 VGND.t23 VBIAS.t0 VBIAS.t1 VGND.t7 sky130_fd_pr__nfet_01v8 ad=0.25 pd=1.5 as=0.25 ps=1.5 w=1 l=1
X26 a_433_1469.t69 a_433_1469.t67 a_433_1469.t68 VGND.t5 sky130_fd_pr__nfet_01v8 ad=0.25 pd=1.5 as=0 ps=0 w=1 l=1
X27 a_433_1469.t93 a_433_1469.t91 a_433_1469.t92 VGND.t7 sky130_fd_pr__nfet_01v8 ad=0.25 pd=1.5 as=0 ps=0 w=1 l=1
X28 VGND.t30 VGND.t28 VGND.t29 VGND.t8 sky130_fd_pr__nfet_01v8 ad=0.5 pd=3 as=0 ps=0 w=1 l=1
X29 VGND.t21 VBIAS.t18 a_433_1469.t5 VGND.t10 sky130_fd_pr__nfet_01v8 ad=0.25 pd=1.5 as=0.25 ps=1.5 w=1 l=1
X30 a_433_1469.t42 a_433_1469.t40 a_433_1469.t41 VGND.t0 sky130_fd_pr__nfet_01v8 ad=0.25 pd=1.5 as=0 ps=0 w=1 l=1
X31 VBIAS.t15 VBIAS.t14 VGND.t24 VGND.t11 sky130_fd_pr__nfet_01v8 ad=0.25 pd=1.5 as=0.25 ps=1.5 w=1 l=1
X32 a_433_1469.t24 a_433_1469.t22 a_433_1469.t23 VGND.t9 sky130_fd_pr__nfet_01v8 ad=0.25 pd=1.5 as=0 ps=0 w=1 l=1
X33 D2.t0 VINM.t7 a_433_1469.t112 VGND.t11 sky130_fd_pr__nfet_01v8 ad=0.25 pd=1.5 as=0.25 ps=1.5 w=1 l=1
X34 a_433_1469.t72 a_433_1469.t70 a_433_1469.t71 VGND.t2 sky130_fd_pr__nfet_01v8 ad=0.25 pd=1.5 as=0 ps=0 w=1 l=1
X35 a_433_1469.t87 a_433_1469.t85 a_433_1469.t86 VGND.t10 sky130_fd_pr__nfet_01v8 ad=0.25 pd=1.5 as=0 ps=0 w=1 l=1
X36 VGND.t33 VGND.t31 VGND.t32 VGND.t5 sky130_fd_pr__nfet_01v8 ad=0.25 pd=1.5 as=0 ps=0 w=1 l=1
X37 VBIAS.t13 VBIAS.t12 VGND.t22 VGND.t6 sky130_fd_pr__nfet_01v8 ad=0.25 pd=1.5 as=0.25 ps=1.5 w=1 l=1
X38 VGND.t27 VBIAS.t16 a_433_1469.t7 VGND.t1 sky130_fd_pr__nfet_01v8 ad=0.25 pd=1.5 as=0.25 ps=1.5 w=1 l=1
X39 a_433_1469.t54 a_433_1469.t52 a_433_1469.t53 VGND.t8 sky130_fd_pr__nfet_01v8 ad=0.5 pd=3 as=0 ps=0 w=1 l=1
X40 D1.t0 VINP.t1 a_433_1469.t14 VGND.t0 sky130_fd_pr__nfet_01v8 ad=0.25 pd=1.5 as=0.25 ps=1.5 w=1 l=1
X41 VGND.t25 VBIAS.t10 VBIAS.t11 VGND.t4 sky130_fd_pr__nfet_01v8 ad=0.25 pd=1.5 as=0.25 ps=1.5 w=1 l=1
X42 a_433_1469.t51 a_433_1469.t49 a_433_1469.t50 VGND.t3 sky130_fd_pr__nfet_01v8 ad=0.25 pd=1.5 as=0 ps=0 w=1 l=1
X43 D1.t5 VINP.t5 a_433_1469.t10 VGND.t6 sky130_fd_pr__nfet_01v8 ad=0.25 pd=1.5 as=0.25 ps=1.5 w=1 l=1
X44 D2.t1 VINM.t3 a_433_1469.t116 VGND.t9 sky130_fd_pr__nfet_01v8 ad=0.25 pd=1.5 as=0.25 ps=1.5 w=1 l=1
X45 VGND.t48 VGND.t46 VGND.t47 VGND.t2 sky130_fd_pr__nfet_01v8 ad=0.25 pd=1.5 as=0 ps=0 w=1 l=1
X46 a_433_1469.t33 a_433_1469.t31 a_433_1469.t32 VGND.t7 sky130_fd_pr__nfet_01v8 ad=0.25 pd=1.5 as=0 ps=0 w=1 l=1
X47 a_433_1469.t115 VINM.t4 D2.t3 VGND.t1 sky130_fd_pr__nfet_01v8 ad=0.25 pd=1.5 as=0.25 ps=1.5 w=1 l=1
X48 a_433_1469.t96 a_433_1469.t94 a_433_1469.t95 VGND.t11 sky130_fd_pr__nfet_01v8 ad=0.25 pd=1.5 as=0 ps=0 w=1 l=1
X49 a_433_1469.t6 VBIAS.t17 VGND.t26 VGND.t0 sky130_fd_pr__nfet_01v8 ad=0.25 pd=1.5 as=0.25 ps=1.5 w=1 l=1
X50 a_433_1469.t78 a_433_1469.t76 a_433_1469.t77 VGND.t8 sky130_fd_pr__nfet_01v8 ad=0.5 pd=3 as=0 ps=0 w=1 l=1
X51 a_433_1469.t0 VBIAS.t23 VGND.t14 VGND.t9 sky130_fd_pr__nfet_01v8 ad=0.25 pd=1.5 as=0.25 ps=1.5 w=1 l=1
X52 a_433_1469.t75 a_433_1469.t73 a_433_1469.t74 VGND.t3 sky130_fd_pr__nfet_01v8 ad=0.25 pd=1.5 as=0 ps=0 w=1 l=1
X53 VGND.t51 VGND.t49 VGND.t50 VGND.t3 sky130_fd_pr__nfet_01v8 ad=0.25 pd=1.5 as=0 ps=0 w=1 l=1
X54 a_433_1469.t27 a_433_1469.t25 a_433_1469.t26 VGND.t10 sky130_fd_pr__nfet_01v8 ad=0.25 pd=1.5 as=0 ps=0 w=1 l=1
X55 a_433_1469.t113 VINM.t6 D2.t2 VGND.t4 sky130_fd_pr__nfet_01v8 ad=0.25 pd=1.5 as=0.25 ps=1.5 w=1 l=1
X56 a_433_1469.t119 VINM.t0 D2.t7 VGND.t7 sky130_fd_pr__nfet_01v8 ad=0.25 pd=1.5 as=0.25 ps=1.5 w=1 l=1
X57 a_433_1469.t90 a_433_1469.t88 a_433_1469.t89 VGND.t6 sky130_fd_pr__nfet_01v8 ad=0.25 pd=1.5 as=0 ps=0 w=1 l=1
X58 VGND.t17 VBIAS.t8 VBIAS.t9 VGND.t7 sky130_fd_pr__nfet_01v8 ad=0.25 pd=1.5 as=0.25 ps=1.5 w=1 l=1
X59 a_433_1469.t105 a_433_1469.t103 a_433_1469.t104 VGND.t1 sky130_fd_pr__nfet_01v8 ad=0.25 pd=1.5 as=0 ps=0 w=1 l=1
X60 VGND.t15 VBIAS.t22 a_433_1469.t1 VGND.t10 sky130_fd_pr__nfet_01v8 ad=0.25 pd=1.5 as=0.25 ps=1.5 w=1 l=1
X61 a_433_1469.t57 a_433_1469.t55 a_433_1469.t56 VGND.t5 sky130_fd_pr__nfet_01v8 ad=0.25 pd=1.5 as=0 ps=0 w=1 l=1
X62 VBIAS.t5 VBIAS.t4 VGND.t19 VGND.t11 sky130_fd_pr__nfet_01v8 ad=0.25 pd=1.5 as=0.25 ps=1.5 w=1 l=1
X63 a_433_1469.t117 VINM.t2 D2.t4 VGND.t10 sky130_fd_pr__nfet_01v8 ad=0.25 pd=1.5 as=0.25 ps=1.5 w=1 l=1
X64 VBIAS.t3 VBIAS.t2 VGND.t16 VGND.t6 sky130_fd_pr__nfet_01v8 ad=0.25 pd=1.5 as=0.25 ps=1.5 w=1 l=1
X65 a_433_1469.t36 a_433_1469.t34 a_433_1469.t35 VGND.t11 sky130_fd_pr__nfet_01v8 ad=0.25 pd=1.5 as=0 ps=0 w=1 l=1
X66 a_433_1469.t60 a_433_1469.t58 a_433_1469.t59 VGND.t2 sky130_fd_pr__nfet_01v8 ad=0.25 pd=1.5 as=0 ps=0 w=1 l=1
X67 a_433_1469.t99 a_433_1469.t97 a_433_1469.t98 VGND.t4 sky130_fd_pr__nfet_01v8 ad=0.25 pd=1.5 as=0 ps=0 w=1 l=1
X68 VGND.t12 VBIAS.t20 a_433_1469.t3 VGND.t1 sky130_fd_pr__nfet_01v8 ad=0.25 pd=1.5 as=0.25 ps=1.5 w=1 l=1
X69 VGND.t20 VBIAS.t6 VBIAS.t7 VGND.t4 sky130_fd_pr__nfet_01v8 ad=0.25 pd=1.5 as=0.25 ps=1.5 w=1 l=1
X70 a_433_1469.t18 a_433_1469.t16 a_433_1469.t17 VGND.t8 sky130_fd_pr__nfet_01v8 ad=0.5 pd=3 as=0 ps=0 w=1 l=1
X71 a_433_1469.t81 a_433_1469.t79 a_433_1469.t80 VGND.t5 sky130_fd_pr__nfet_01v8 ad=0.25 pd=1.5 as=0 ps=0 w=1 l=1
C0 D1 VINP 0.76513f
C1 VBIAS VINP 0.00141f
C2 D2 VINM 0.70161f
C3 D2 D1 0.37157f
C4 D2 VBIAS 0.06067f
C5 VINM D1 0.17787f
C6 VBIAS VINM 0.05175f
C7 VBIAS D1 0.03009f
C8 D2 VINP 0.13432f
C9 VINM VINP 1.41348f
R0 VBIAS.n19 VBIAS.n18 184.74
R1 VBIAS.n24 VBIAS.n23 184.74
R2 VBIAS.n30 VBIAS.n29 184.74
R3 VBIAS.n35 VBIAS.n34 184.74
R4 VBIAS.n41 VBIAS.n40 184.74
R5 VBIAS.n46 VBIAS.n45 184.74
R6 VBIAS.n52 VBIAS.n51 184.74
R7 VBIAS.n74 VBIAS.n73 184.74
R8 VBIAS.n79 VBIAS.n78 184.74
R9 VBIAS.n85 VBIAS.n84 184.74
R10 VBIAS.n90 VBIAS.n89 184.74
R11 VBIAS.n96 VBIAS.n95 184.74
R12 VBIAS.n101 VBIAS.n100 184.74
R13 VBIAS.n106 VBIAS.n105 184.74
R14 VBIAS.n27 VBIAS.n12 97.4646
R15 VBIAS.n38 VBIAS.n7 97.4646
R16 VBIAS.n82 VBIAS.n67 97.4622
R17 VBIAS.n93 VBIAS.n62 97.4622
R18 VBIAS.n17 VBIAS.t20 85.142
R19 VBIAS.n72 VBIAS.t16 85.142
R20 VBIAS.n20 VBIAS.n19 77.1778
R21 VBIAS.n25 VBIAS.n24 77.1778
R22 VBIAS.n31 VBIAS.n30 77.1778
R23 VBIAS.n36 VBIAS.n35 77.1778
R24 VBIAS.n42 VBIAS.n41 77.1778
R25 VBIAS.n47 VBIAS.n46 77.1778
R26 VBIAS.n51 VBIAS.n50 77.1778
R27 VBIAS.n75 VBIAS.n74 77.1778
R28 VBIAS.n80 VBIAS.n79 77.1778
R29 VBIAS.n86 VBIAS.n85 77.1778
R30 VBIAS.n91 VBIAS.n90 77.1778
R31 VBIAS.n97 VBIAS.n96 77.1778
R32 VBIAS.n102 VBIAS.n101 77.1778
R33 VBIAS.n107 VBIAS.n106 77.1778
R34 VBIAS.n12 VBIAS.t5 30.0005
R35 VBIAS.n12 VBIAS.t7 30.0005
R36 VBIAS.n7 VBIAS.t3 30.0005
R37 VBIAS.n7 VBIAS.t9 30.0005
R38 VBIAS.n67 VBIAS.t15 30.0005
R39 VBIAS.n67 VBIAS.t11 30.0005
R40 VBIAS.n62 VBIAS.t13 30.0005
R41 VBIAS.n62 VBIAS.t1 30.0005
R42 VBIAS.n18 VBIAS.n16 27.1064
R43 VBIAS.n23 VBIAS.n14 27.1064
R44 VBIAS.n29 VBIAS.n11 27.1064
R45 VBIAS.n34 VBIAS.n9 27.1064
R46 VBIAS.n40 VBIAS.n6 27.1064
R47 VBIAS.n45 VBIAS.n4 27.1064
R48 VBIAS.n52 VBIAS.n2 27.1064
R49 VBIAS.n73 VBIAS.n71 27.1064
R50 VBIAS.n78 VBIAS.n69 27.1064
R51 VBIAS.n84 VBIAS.n66 27.1064
R52 VBIAS.n89 VBIAS.n64 27.1064
R53 VBIAS.n95 VBIAS.n61 27.1064
R54 VBIAS.n100 VBIAS.n59 27.1064
R55 VBIAS.n105 VBIAS.n57 27.1064
R56 VBIAS.n19 VBIAS.t21 24.1005
R57 VBIAS.n24 VBIAS.t6 24.1005
R58 VBIAS.n30 VBIAS.t4 24.1005
R59 VBIAS.n35 VBIAS.t8 24.1005
R60 VBIAS.n41 VBIAS.t2 24.1005
R61 VBIAS.n46 VBIAS.t22 24.1005
R62 VBIAS.n51 VBIAS.t23 24.1005
R63 VBIAS.n74 VBIAS.t17 24.1005
R64 VBIAS.n79 VBIAS.t10 24.1005
R65 VBIAS.n85 VBIAS.t14 24.1005
R66 VBIAS.n90 VBIAS.t0 24.1005
R67 VBIAS.n96 VBIAS.t12 24.1005
R68 VBIAS.n101 VBIAS.t18 24.1005
R69 VBIAS.n106 VBIAS.t19 24.1005
R70 VBIAS.n108 VBIAS.n107 23.1301
R71 VBIAS.n21 VBIAS.n20 23.0638
R72 VBIAS.n26 VBIAS.n25 23.0638
R73 VBIAS.n32 VBIAS.n31 23.0638
R74 VBIAS.n37 VBIAS.n36 23.0638
R75 VBIAS.n43 VBIAS.n42 23.0638
R76 VBIAS.n48 VBIAS.n47 23.0638
R77 VBIAS.n50 VBIAS.n49 23.0638
R78 VBIAS.n76 VBIAS.n75 23.0638
R79 VBIAS.n81 VBIAS.n80 23.0638
R80 VBIAS.n87 VBIAS.n86 23.0638
R81 VBIAS.n92 VBIAS.n91 23.0638
R82 VBIAS.n98 VBIAS.n97 23.0638
R83 VBIAS.n103 VBIAS.n102 23.0638
R84 VBIAS.n20 VBIAS.n16 11.3247
R85 VBIAS.n25 VBIAS.n14 11.3247
R86 VBIAS.n31 VBIAS.n11 11.3247
R87 VBIAS.n36 VBIAS.n9 11.3247
R88 VBIAS.n42 VBIAS.n6 11.3247
R89 VBIAS.n47 VBIAS.n4 11.3247
R90 VBIAS.n50 VBIAS.n2 11.3247
R91 VBIAS.n75 VBIAS.n71 11.3247
R92 VBIAS.n80 VBIAS.n69 11.3247
R93 VBIAS.n86 VBIAS.n66 11.3247
R94 VBIAS.n91 VBIAS.n64 11.3247
R95 VBIAS.n97 VBIAS.n61 11.3247
R96 VBIAS.n102 VBIAS.n59 11.3247
R97 VBIAS.n107 VBIAS.n57 11.3247
R98 VBIAS.n53 VBIAS.n52 9.36679
R99 VBIAS.n2 VBIAS.n1 9.3005
R100 VBIAS.n45 VBIAS.n44 9.3005
R101 VBIAS.n4 VBIAS.n3 9.3005
R102 VBIAS.n40 VBIAS.n39 9.3005
R103 VBIAS.n6 VBIAS.n5 9.3005
R104 VBIAS.n34 VBIAS.n33 9.3005
R105 VBIAS.n9 VBIAS.n8 9.3005
R106 VBIAS.n29 VBIAS.n28 9.3005
R107 VBIAS.n11 VBIAS.n10 9.3005
R108 VBIAS.n23 VBIAS.n22 9.3005
R109 VBIAS.n14 VBIAS.n13 9.3005
R110 VBIAS.n18 VBIAS.n17 9.3005
R111 VBIAS.n16 VBIAS.n15 9.3005
R112 VBIAS.n105 VBIAS.n104 9.3005
R113 VBIAS.n57 VBIAS.n56 9.3005
R114 VBIAS.n100 VBIAS.n99 9.3005
R115 VBIAS.n59 VBIAS.n58 9.3005
R116 VBIAS.n95 VBIAS.n94 9.3005
R117 VBIAS.n61 VBIAS.n60 9.3005
R118 VBIAS.n89 VBIAS.n88 9.3005
R119 VBIAS.n64 VBIAS.n63 9.3005
R120 VBIAS.n84 VBIAS.n83 9.3005
R121 VBIAS.n66 VBIAS.n65 9.3005
R122 VBIAS.n78 VBIAS.n77 9.3005
R123 VBIAS.n69 VBIAS.n68 9.3005
R124 VBIAS.n73 VBIAS.n72 9.3005
R125 VBIAS.n71 VBIAS.n70 9.3005
R126 VBIAS.n110 VBIAS.n54 6.19395
R127 VBIAS.n54 VBIAS.n0 4.56105
R128 VBIAS.n109 VBIAS.n55 4.56105
R129 VBIAS.n54 VBIAS.n53 4.56007
R130 VBIAS.n109 VBIAS.n108 4.56007
R131 VBIAS.n110 VBIAS.n109 2.27332
R132 VBIAS.n44 VBIAS.n43 0.3755
R133 VBIAS.n33 VBIAS.n32 0.3755
R134 VBIAS.n22 VBIAS.n21 0.3755
R135 VBIAS.n99 VBIAS.n98 0.3755
R136 VBIAS.n88 VBIAS.n87 0.3755
R137 VBIAS.n77 VBIAS.n76 0.3755
R138 VBIAS.n49 VBIAS.n48 0.37397
R139 VBIAS.n104 VBIAS.n103 0.37397
R140 VBIAS VBIAS.n110 0.271106
R141 VBIAS.n38 VBIAS.n37 0.192808
R142 VBIAS.n27 VBIAS.n26 0.192808
R143 VBIAS.n94 VBIAS.n93 0.190404
R144 VBIAS.n83 VBIAS.n82 0.188
R145 VBIAS.n82 VBIAS.n81 0.188
R146 VBIAS.n93 VBIAS.n92 0.185596
R147 VBIAS.n39 VBIAS.n38 0.183192
R148 VBIAS.n28 VBIAS.n27 0.183192
R149 VBIAS.n48 VBIAS.n3 0.173577
R150 VBIAS.n44 VBIAS.n3 0.173577
R151 VBIAS.n43 VBIAS.n5 0.173577
R152 VBIAS.n39 VBIAS.n5 0.173577
R153 VBIAS.n37 VBIAS.n8 0.173577
R154 VBIAS.n33 VBIAS.n8 0.173577
R155 VBIAS.n32 VBIAS.n10 0.173577
R156 VBIAS.n28 VBIAS.n10 0.173577
R157 VBIAS.n26 VBIAS.n13 0.173577
R158 VBIAS.n22 VBIAS.n13 0.173577
R159 VBIAS.n21 VBIAS.n15 0.173577
R160 VBIAS.n17 VBIAS.n15 0.173577
R161 VBIAS.n103 VBIAS.n58 0.173577
R162 VBIAS.n99 VBIAS.n58 0.173577
R163 VBIAS.n98 VBIAS.n60 0.173577
R164 VBIAS.n94 VBIAS.n60 0.173577
R165 VBIAS.n92 VBIAS.n63 0.173577
R166 VBIAS.n88 VBIAS.n63 0.173577
R167 VBIAS.n87 VBIAS.n65 0.173577
R168 VBIAS.n83 VBIAS.n65 0.173577
R169 VBIAS.n81 VBIAS.n68 0.173577
R170 VBIAS.n77 VBIAS.n68 0.173577
R171 VBIAS.n76 VBIAS.n70 0.173577
R172 VBIAS.n72 VBIAS.n70 0.173577
R173 VBIAS.n49 VBIAS.n0 0.0857273
R174 VBIAS.n104 VBIAS.n55 0.0857273
R175 VBIAS.n53 VBIAS.n1 0.0705758
R176 VBIAS.n108 VBIAS.n56 0.0705758
R177 VBIAS.n1 VBIAS.n0 0.0516364
R178 VBIAS.n56 VBIAS.n55 0.0516364
R179 D2.n1 D2.n0 103.35
R180 D2.n3 D2.n2 103.35
R181 D2.n7 D2.n6 103.209
R182 D2.n5 D2.n4 103.207
R183 D2.n2 D2.t5 30.0005
R184 D2.n2 D2.t3 30.0005
R185 D2.n0 D2.t0 30.0005
R186 D2.n0 D2.t2 30.0005
R187 D2.n4 D2.t6 30.0005
R188 D2.n4 D2.t7 30.0005
R189 D2.n6 D2.t1 30.0005
R190 D2.n6 D2.t4 30.0005
R191 D2.n5 D2.n3 17.0621
R192 D2.n8 D2.n1 9.04611
R193 D2.n8 D2.n7 8.14496
R194 D2 D2.n8 1.77113
R195 D2.n3 D2.n1 1.44843
R196 D2.n7 D2.n5 1.44839
R197 D1.n1 D1.n0 103.037
R198 D1.n3 D1.n2 103.035
R199 D1.n7 D1.n6 102.894
R200 D1.n5 D1.n4 102.891
R201 D1.n2 D1.t5 30.0005
R202 D1.n2 D1.t7 30.0005
R203 D1.n0 D1.t2 30.0005
R204 D1.n0 D1.t3 30.0005
R205 D1.n4 D1.t0 30.0005
R206 D1.n4 D1.t1 30.0005
R207 D1.n6 D1.t4 30.0005
R208 D1.n6 D1.t6 30.0005
R209 D1.n5 D1.n3 15.5391
R210 D1.n8 D1.n7 9.57622
R211 D1.n8 D1.n1 6.09179
R212 D1 D1.n8 1.90501
R213 D1.n7 D1.n5 1.43886
R214 D1.n3 D1.n1 1.43884
R215 VINM.n4 VINM.n3 184.74
R216 VINM.n14 VINM.n13 184.74
R217 VINM.n25 VINM.n24 184.74
R218 VINM.n37 VINM.n36 184.74
R219 VINM.n47 VINM.n46 184.74
R220 VINM.n58 VINM.n57 184.74
R221 VINM.n69 VINM.n68 184.74
R222 VINM.n80 VINM.n79 184.74
R223 VINM.n5 VINM.n4 77.1778
R224 VINM.n15 VINM.n14 77.1778
R225 VINM.n26 VINM.n25 77.1778
R226 VINM.n36 VINM.n35 77.1778
R227 VINM.n48 VINM.n47 77.1778
R228 VINM.n59 VINM.n58 77.1778
R229 VINM.n70 VINM.n69 77.1778
R230 VINM.n81 VINM.n80 77.1778
R231 VINM.n3 VINM.n2 27.1064
R232 VINM.n13 VINM.n11 27.1064
R233 VINM.n24 VINM.n22 27.1064
R234 VINM.n37 VINM.n33 27.1064
R235 VINM.n46 VINM.n44 27.1064
R236 VINM.n57 VINM.n55 27.1064
R237 VINM.n68 VINM.n66 27.1064
R238 VINM.n79 VINM.n77 27.1064
R239 VINM.n4 VINM.t4 24.1005
R240 VINM.n14 VINM.t5 24.1005
R241 VINM.n25 VINM.t6 24.1005
R242 VINM.n36 VINM.t7 24.1005
R243 VINM.n47 VINM.t0 24.1005
R244 VINM.n58 VINM.t1 24.1005
R245 VINM.n69 VINM.t2 24.1005
R246 VINM.n80 VINM.t3 24.1005
R247 VINM.n60 VINM.n59 23.1414
R248 VINM.n71 VINM.n70 23.1414
R249 VINM.n82 VINM.n81 23.1414
R250 VINM.n6 VINM.n5 23.1396
R251 VINM.n16 VINM.n15 23.1396
R252 VINM.n49 VINM.n48 23.1377
R253 VINM.n27 VINM.n26 23.1339
R254 VINM.n35 VINM.n34 23.1339
R255 VINM.n5 VINM.n2 11.3247
R256 VINM.n15 VINM.n11 11.3247
R257 VINM.n26 VINM.n22 11.3247
R258 VINM.n35 VINM.n33 11.3247
R259 VINM.n48 VINM.n44 11.3247
R260 VINM.n59 VINM.n55 11.3247
R261 VINM.n70 VINM.n66 11.3247
R262 VINM.n81 VINM.n77 11.3247
R263 VINM.n24 VINM.n23 9.38194
R264 VINM.n38 VINM.n37 9.38194
R265 VINM.n46 VINM.n45 9.37815
R266 VINM.n3 VINM.n0 9.37626
R267 VINM.n13 VINM.n12 9.37626
R268 VINM.n57 VINM.n56 9.37436
R269 VINM.n68 VINM.n67 9.37436
R270 VINM.n79 VINM.n78 9.37436
R271 VINM.n2 VINM.n1 9.3005
R272 VINM.n11 VINM.n10 9.3005
R273 VINM.n22 VINM.n21 9.3005
R274 VINM.n33 VINM.n32 9.3005
R275 VINM.n44 VINM.n43 9.3005
R276 VINM.n55 VINM.n54 9.3005
R277 VINM.n66 VINM.n65 9.3005
R278 VINM.n77 VINM.n76 9.3005
R279 VINM.n7 VINM.n0 4.56105
R280 VINM.n7 VINM.n6 4.56007
R281 VINM.n12 VINM.n9 4.5005
R282 VINM.n17 VINM.n16 4.5005
R283 VINM.n28 VINM.n27 4.5005
R284 VINM.n23 VINM.n20 4.5005
R285 VINM.n39 VINM.n38 4.5005
R286 VINM.n34 VINM.n31 4.5005
R287 VINM.n45 VINM.n42 4.5005
R288 VINM.n50 VINM.n49 4.5005
R289 VINM.n56 VINM.n53 4.5005
R290 VINM.n61 VINM.n60 4.5005
R291 VINM.n67 VINM.n64 4.5005
R292 VINM.n72 VINM.n71 4.5005
R293 VINM.n78 VINM.n75 4.5005
R294 VINM.n83 VINM.n82 4.5005
R295 VINM.n18 VINM.n17 3.42565
R296 VINM.n9 VINM.n8 3.42565
R297 VINM.n29 VINM.n28 3.42565
R298 VINM.n20 VINM.n19 3.42565
R299 VINM.n40 VINM.n39 3.42565
R300 VINM.n31 VINM.n30 3.42565
R301 VINM.n51 VINM.n50 3.42565
R302 VINM.n42 VINM.n41 3.42565
R303 VINM.n62 VINM.n61 3.42565
R304 VINM.n53 VINM.n52 3.42565
R305 VINM.n73 VINM.n72 3.42565
R306 VINM.n64 VINM.n63 3.42565
R307 VINM.n84 VINM.n83 3.42565
R308 VINM.n75 VINM.n74 3.42565
R309 VINM.n8 VINM.n7 1.85459
R310 VINM VINM.n84 0.850773
R311 VINM.n41 VINM.n40 0.393591
R312 VINM.n19 VINM.n18 0.159303
R313 VINM.n74 VINM.n73 0.157167
R314 VINM.n63 VINM.n62 0.157167
R315 VINM.n52 VINM.n51 0.155742
R316 VINM.n30 VINM.n29 0.152894
R317 VINM.n17 VINM.n9 0.121712
R318 VINM.n28 VINM.n20 0.121712
R319 VINM.n39 VINM.n31 0.121712
R320 VINM.n50 VINM.n42 0.121712
R321 VINM.n61 VINM.n53 0.121712
R322 VINM.n72 VINM.n64 0.121712
R323 VINM.n83 VINM.n75 0.121712
R324 VINM.n27 VINM.n21 0.0667879
R325 VINM.n34 VINM.n32 0.0667879
R326 VINM.n49 VINM.n43 0.063
R327 VINM.n56 VINM.n54 0.063
R328 VINM.n67 VINM.n65 0.063
R329 VINM.n78 VINM.n76 0.063
R330 VINM.n6 VINM.n1 0.0611061
R331 VINM.n1 VINM.n0 0.0611061
R332 VINM.n16 VINM.n10 0.0611061
R333 VINM.n12 VINM.n10 0.0611061
R334 VINM.n45 VINM.n43 0.0592121
R335 VINM.n60 VINM.n54 0.0592121
R336 VINM.n71 VINM.n65 0.0592121
R337 VINM.n82 VINM.n76 0.0592121
R338 VINM.n84 VINM.n74 0.0574697
R339 VINM.n73 VINM.n63 0.0574697
R340 VINM.n62 VINM.n52 0.0574697
R341 VINM.n51 VINM.n41 0.0574697
R342 VINM.n40 VINM.n30 0.0574697
R343 VINM.n29 VINM.n19 0.0574697
R344 VINM.n18 VINM.n8 0.0574697
R345 VINM.n23 VINM.n21 0.0554242
R346 VINM.n38 VINM.n32 0.0554242
R347 VINP.n36 VINP.n35 184.74
R348 VINP.n41 VINP.n40 184.74
R349 VINP.n46 VINP.n45 184.74
R350 VINP.n52 VINP.n51 184.74
R351 VINP.n19 VINP.n18 184.74
R352 VINP.n24 VINP.n23 184.74
R353 VINP.n29 VINP.n28 184.74
R354 VINP.n17 VINP.t0 85.042
R355 VINP.n37 VINP.n36 77.1778
R356 VINP.n42 VINP.n41 77.1778
R357 VINP.n47 VINP.n46 77.1778
R358 VINP.n51 VINP.n50 77.1778
R359 VINP.n20 VINP.n19 77.1778
R360 VINP.n25 VINP.n24 77.1778
R361 VINP.n30 VINP.n29 77.1778
R362 VINP.n35 VINP.n8 27.1064
R363 VINP.n40 VINP.n6 27.1064
R364 VINP.n45 VINP.n4 27.1064
R365 VINP.n52 VINP.n2 27.1064
R366 VINP.n18 VINP.n16 27.1064
R367 VINP.n23 VINP.n14 27.1064
R368 VINP.n28 VINP.n12 27.1064
R369 VINP.n36 VINP.t4 24.1005
R370 VINP.n41 VINP.t5 24.1005
R371 VINP.n46 VINP.t6 24.1005
R372 VINP.n51 VINP.t7 24.1005
R373 VINP.n19 VINP.t1 24.1005
R374 VINP.n24 VINP.t2 24.1005
R375 VINP.n29 VINP.t3 24.1005
R376 VINP.n31 VINP.n30 23.1225
R377 VINP.n38 VINP.n37 23.0638
R378 VINP.n43 VINP.n42 23.0638
R379 VINP.n48 VINP.n47 23.0638
R380 VINP.n50 VINP.n49 23.0638
R381 VINP.n21 VINP.n20 23.0638
R382 VINP.n26 VINP.n25 23.0638
R383 VINP.n37 VINP.n8 11.3247
R384 VINP.n42 VINP.n6 11.3247
R385 VINP.n47 VINP.n4 11.3247
R386 VINP.n50 VINP.n2 11.3247
R387 VINP.n20 VINP.n16 11.3247
R388 VINP.n25 VINP.n14 11.3247
R389 VINP.n30 VINP.n12 11.3247
R390 VINP.n53 VINP.n52 9.36489
R391 VINP.n35 VINP.n34 9.3327
R392 VINP.n2 VINP.n1 9.3005
R393 VINP.n45 VINP.n44 9.3005
R394 VINP.n4 VINP.n3 9.3005
R395 VINP.n40 VINP.n39 9.3005
R396 VINP.n6 VINP.n5 9.3005
R397 VINP.n9 VINP.n8 9.3005
R398 VINP.n28 VINP.n27 9.3005
R399 VINP.n12 VINP.n11 9.3005
R400 VINP.n23 VINP.n22 9.3005
R401 VINP.n14 VINP.n13 9.3005
R402 VINP.n18 VINP.n17 9.3005
R403 VINP.n16 VINP.n15 9.3005
R404 VINP.n33 VINP.n7 4.62171
R405 VINP.n32 VINP.n10 4.62171
R406 VINP.n54 VINP.n0 4.56105
R407 VINP.n54 VINP.n53 4.56007
R408 VINP.n34 VINP.n33 4.5005
R409 VINP.n32 VINP.n31 4.5005
R410 VINP VINP.n54 2.54321
R411 VINP.n33 VINP.n32 1.00618
R412 VINP.n49 VINP.n48 0.295955
R413 VINP.n44 VINP.n43 0.295955
R414 VINP.n39 VINP.n38 0.295955
R415 VINP.n27 VINP.n26 0.295955
R416 VINP.n22 VINP.n21 0.295955
R417 VINP.n48 VINP.n3 0.136864
R418 VINP.n44 VINP.n3 0.136864
R419 VINP.n43 VINP.n5 0.136864
R420 VINP.n39 VINP.n5 0.136864
R421 VINP.n26 VINP.n13 0.136864
R422 VINP.n22 VINP.n13 0.136864
R423 VINP.n21 VINP.n15 0.136864
R424 VINP.n17 VINP.n15 0.136864
R425 VINP.n38 VINP.n7 0.119818
R426 VINP.n34 VINP.n9 0.104667
R427 VINP.n27 VINP.n10 0.093303
R428 VINP.n49 VINP.n0 0.0876212
R429 VINP.n31 VINP.n11 0.0781515
R430 VINP.n53 VINP.n1 0.0724697
R431 VINP.n1 VINP.n0 0.0497424
R432 VINP.n11 VINP.n10 0.0440606
R433 VINP.n9 VINP.n7 0.0175455
R434 VGND.n613 VGND.n324 723.761
R435 VGND.n942 VGND.n10 723.761
R436 VGND.n944 VGND.n3 698.066
R437 VGND.n611 VGND.n327 698.066
R438 VGND.n582 VGND.n581 585
R439 VGND.n344 VGND.n340 585
R440 VGND.n434 VGND.n433 585
R441 VGND.n431 VGND.n343 585
R442 VGND.n430 VGND.n429 585
R443 VGND.n423 VGND.n346 585
R444 VGND.n424 VGND.n325 585
R445 VGND.n425 VGND.n424 585
R446 VGND.n422 VGND.n348 585
R447 VGND.n420 VGND.n419 585
R448 VGND.n350 VGND.n349 585
R449 VGND.n415 VGND.n414 585
R450 VGND.n412 VGND.n352 585
R451 VGND.n410 VGND.n409 585
R452 VGND.n354 VGND.n353 585
R453 VGND.n405 VGND.n404 585
R454 VGND.n402 VGND.n356 585
R455 VGND.n400 VGND.n399 585
R456 VGND.n357 VGND.n325 585
R457 VGND.n358 VGND.n357 585
R458 VGND.n395 VGND.n394 585
R459 VGND.n392 VGND.n360 585
R460 VGND.n391 VGND.n390 585
R461 VGND.n384 VGND.n362 585
R462 VGND.n386 VGND.n385 585
R463 VGND.n382 VGND.n364 585
R464 VGND.n381 VGND.n325 585
R465 VGND.n381 VGND.n380 585
R466 VGND.n366 VGND.n365 585
R467 VGND.n376 VGND.n375 585
R468 VGND.n373 VGND.n368 585
R469 VGND.n371 VGND.n370 585
R470 VGND.n325 VGND.n324 585
R471 VGND.n324 VGND.n323 585
R472 VGND.n612 VGND.n326 585
R473 VGND.n577 VGND.n326 585
R474 VGND.n438 VGND.n318 585
R475 VGND.n576 VGND.n438 585
R476 VGND.n620 VGND.n319 585
R477 VGND.n575 VGND.n319 585
R478 VGND.n439 VGND.n311 585
R479 VGND.n440 VGND.n439 585
R480 VGND.n630 VGND.n312 585
R481 VGND.n571 VGND.n312 585
R482 VGND.n442 VGND.n304 585
R483 VGND.n570 VGND.n442 585
R484 VGND.n638 VGND.n305 585
R485 VGND.n569 VGND.n305 585
R486 VGND.n443 VGND.n297 585
R487 VGND.n444 VGND.n443 585
R488 VGND.n658 VGND.n298 585
R489 VGND.n565 VGND.n298 585
R490 VGND.n446 VGND.n289 585
R491 VGND.n564 VGND.n446 585
R492 VGND.n666 VGND.n290 585
R493 VGND.n563 VGND.n290 585
R494 VGND.n447 VGND.n291 585
R495 VGND.n448 VGND.n447 585
R496 VGND.n675 VGND.n283 585
R497 VGND.n559 VGND.n283 585
R498 VGND.n450 VGND.n275 585
R499 VGND.n558 VGND.n450 585
R500 VGND.n683 VGND.n276 585
R501 VGND.n557 VGND.n276 585
R502 VGND.n451 VGND.n277 585
R503 VGND.n452 VGND.n451 585
R504 VGND.n691 VGND.n266 585
R505 VGND.n553 VGND.n266 585
R506 VGND.n454 VGND.n258 585
R507 VGND.n552 VGND.n454 585
R508 VGND.n699 VGND.n259 585
R509 VGND.n551 VGND.n259 585
R510 VGND.n455 VGND.n260 585
R511 VGND.n456 VGND.n455 585
R512 VGND.n708 VGND.n252 585
R513 VGND.n547 VGND.n252 585
R514 VGND.n458 VGND.n244 585
R515 VGND.n546 VGND.n458 585
R516 VGND.n716 VGND.n245 585
R517 VGND.n545 VGND.n245 585
R518 VGND.n459 VGND.n246 585
R519 VGND.n460 VGND.n459 585
R520 VGND.n724 VGND.n235 585
R521 VGND.n541 VGND.n235 585
R522 VGND.n462 VGND.n227 585
R523 VGND.n540 VGND.n462 585
R524 VGND.n732 VGND.n228 585
R525 VGND.n539 VGND.n228 585
R526 VGND.n463 VGND.n229 585
R527 VGND.n464 VGND.n463 585
R528 VGND.n741 VGND.n221 585
R529 VGND.n535 VGND.n221 585
R530 VGND.n466 VGND.n213 585
R531 VGND.n534 VGND.n466 585
R532 VGND.n749 VGND.n214 585
R533 VGND.n533 VGND.n214 585
R534 VGND.n467 VGND.n215 585
R535 VGND.n468 VGND.n467 585
R536 VGND.n757 VGND.n204 585
R537 VGND.n529 VGND.n204 585
R538 VGND.n470 VGND.n197 585
R539 VGND.n528 VGND.n470 585
R540 VGND.n765 VGND.n198 585
R541 VGND.n527 VGND.n198 585
R542 VGND.n471 VGND.n190 585
R543 VGND.n472 VGND.n471 585
R544 VGND.n773 VGND.n191 585
R545 VGND.n523 VGND.n191 585
R546 VGND.n474 VGND.n183 585
R547 VGND.n522 VGND.n474 585
R548 VGND.n781 VGND.n184 585
R549 VGND.n521 VGND.n184 585
R550 VGND.n475 VGND.n176 585
R551 VGND.n476 VGND.n475 585
R552 VGND.n793 VGND.n177 585
R553 VGND.n517 VGND.n177 585
R554 VGND.n478 VGND.n169 585
R555 VGND.n516 VGND.n478 585
R556 VGND.n801 VGND.n170 585
R557 VGND.n515 VGND.n170 585
R558 VGND.n479 VGND.n162 585
R559 VGND.n480 VGND.n479 585
R560 VGND.n809 VGND.n163 585
R561 VGND.n511 VGND.n163 585
R562 VGND.n482 VGND.n155 585
R563 VGND.n510 VGND.n482 585
R564 VGND.n817 VGND.n156 585
R565 VGND.n509 VGND.n156 585
R566 VGND.n483 VGND.n148 585
R567 VGND.n484 VGND.n483 585
R568 VGND.n829 VGND.n149 585
R569 VGND.n505 VGND.n149 585
R570 VGND.n486 VGND.n141 585
R571 VGND.n504 VGND.n486 585
R572 VGND.n837 VGND.n142 585
R573 VGND.n503 VGND.n142 585
R574 VGND.n487 VGND.n134 585
R575 VGND.n488 VGND.n487 585
R576 VGND.n857 VGND.n135 585
R577 VGND.n499 VGND.n135 585
R578 VGND.n490 VGND.n127 585
R579 VGND.n498 VGND.n490 585
R580 VGND.n865 VGND.n128 585
R581 VGND.n497 VGND.n128 585
R582 VGND.n491 VGND.n118 585
R583 VGND.n492 VGND.n491 585
R584 VGND.n879 VGND.n119 585
R585 VGND.n493 VGND.n119 585
R586 VGND.n111 VGND.n109 585
R587 VGND.n109 VGND.n108 585
R588 VGND.n888 VGND.n887 585
R589 VGND.n889 VGND.n888 585
R590 VGND.n110 VGND.n6 585
R591 VGND.n110 VGND.n106 585
R592 VGND.n943 VGND.n7 585
R593 VGND.n893 VGND.n7 585
R594 VGND.n74 VGND.n8 585
R595 VGND.n105 VGND.n74 585
R596 VGND.n77 VGND.n75 585
R597 VGND.n101 VGND.n79 585
R598 VGND.n80 VGND.n8 585
R599 VGND.n100 VGND.n80 585
R600 VGND.n99 VGND.n81 585
R601 VGND.n85 VGND.n82 585
R602 VGND.n86 VGND.n8 585
R603 VGND.n95 VGND.n86 585
R604 VGND.n94 VGND.n87 585
R605 VGND.n93 VGND.n91 585
R606 VGND.n90 VGND.n2 585
R607 VGND.n946 VGND.n3 585
R608 VGND.n12 VGND.n10 585
R609 VGND.n937 VGND.n16 585
R610 VGND.n936 VGND.n17 585
R611 VGND.n935 VGND.n19 585
R612 VGND.n22 VGND.n20 585
R613 VGND.n931 VGND.n24 585
R614 VGND.n930 VGND.n25 585
R615 VGND.n929 VGND.n27 585
R616 VGND.n30 VGND.n28 585
R617 VGND.n925 VGND.n32 585
R618 VGND.n924 VGND.n33 585
R619 VGND.n923 VGND.n35 585
R620 VGND.n38 VGND.n36 585
R621 VGND.n919 VGND.n40 585
R622 VGND.n918 VGND.n41 585
R623 VGND.n917 VGND.n43 585
R624 VGND.n46 VGND.n44 585
R625 VGND.n913 VGND.n48 585
R626 VGND.n912 VGND.n49 585
R627 VGND.n911 VGND.n51 585
R628 VGND.n54 VGND.n52 585
R629 VGND.n907 VGND.n56 585
R630 VGND.n906 VGND.n57 585
R631 VGND.n905 VGND.n59 585
R632 VGND.n62 VGND.n60 585
R633 VGND.n901 VGND.n64 585
R634 VGND.n900 VGND.n65 585
R635 VGND.n899 VGND.n67 585
R636 VGND.n70 VGND.n68 585
R637 VGND.n895 VGND.n72 585
R638 VGND.n943 VGND.n942 585
R639 VGND.n942 VGND.n941 585
R640 VGND.n9 VGND.n6 585
R641 VGND.n11 VGND.n9 585
R642 VGND.n887 VGND.n886 585
R643 VGND.n886 VGND.n885 585
R644 VGND.n113 VGND.n111 585
R645 VGND.n114 VGND.n113 585
R646 VGND.n880 VGND.n879 585
R647 VGND.n881 VGND.n880 585
R648 VGND.n118 VGND.n117 585
R649 VGND.n117 VGND.n116 585
R650 VGND.n865 VGND.n864 585
R651 VGND.n864 VGND.n863 585
R652 VGND.n129 VGND.n127 585
R653 VGND.n130 VGND.n129 585
R654 VGND.n858 VGND.n857 585
R655 VGND.n859 VGND.n858 585
R656 VGND.n134 VGND.n133 585
R657 VGND.n133 VGND.n132 585
R658 VGND.n837 VGND.n836 585
R659 VGND.n836 VGND.n835 585
R660 VGND.n143 VGND.n141 585
R661 VGND.n144 VGND.n143 585
R662 VGND.n830 VGND.n829 585
R663 VGND.n831 VGND.n830 585
R664 VGND.n148 VGND.n147 585
R665 VGND.n147 VGND.n146 585
R666 VGND.n817 VGND.n816 585
R667 VGND.n816 VGND.n815 585
R668 VGND.n157 VGND.n155 585
R669 VGND.n158 VGND.n157 585
R670 VGND.n810 VGND.n809 585
R671 VGND.n811 VGND.n810 585
R672 VGND.n162 VGND.n161 585
R673 VGND.n161 VGND.n160 585
R674 VGND.n801 VGND.n800 585
R675 VGND.n800 VGND.n799 585
R676 VGND.n171 VGND.n169 585
R677 VGND.n172 VGND.n171 585
R678 VGND.n794 VGND.n793 585
R679 VGND.n795 VGND.n794 585
R680 VGND.n176 VGND.n175 585
R681 VGND.n175 VGND.n174 585
R682 VGND.n781 VGND.n780 585
R683 VGND.n780 VGND.n779 585
R684 VGND.n185 VGND.n183 585
R685 VGND.n186 VGND.n185 585
R686 VGND.n774 VGND.n773 585
R687 VGND.n775 VGND.n774 585
R688 VGND.n190 VGND.n189 585
R689 VGND.n189 VGND.n188 585
R690 VGND.n765 VGND.n764 585
R691 VGND.n764 VGND.n763 585
R692 VGND.n199 VGND.n197 585
R693 VGND.n200 VGND.n199 585
R694 VGND.n758 VGND.n757 585
R695 VGND.n759 VGND.n758 585
R696 VGND.n215 VGND.n203 585
R697 VGND.n203 VGND.n202 585
R698 VGND.n749 VGND.n748 585
R699 VGND.n748 VGND.n747 585
R700 VGND.n216 VGND.n213 585
R701 VGND.n217 VGND.n216 585
R702 VGND.n742 VGND.n741 585
R703 VGND.n743 VGND.n742 585
R704 VGND.n229 VGND.n220 585
R705 VGND.n220 VGND.n219 585
R706 VGND.n732 VGND.n731 585
R707 VGND.n731 VGND.n730 585
R708 VGND.n230 VGND.n227 585
R709 VGND.n231 VGND.n230 585
R710 VGND.n725 VGND.n724 585
R711 VGND.n726 VGND.n725 585
R712 VGND.n246 VGND.n234 585
R713 VGND.n234 VGND.n233 585
R714 VGND.n716 VGND.n715 585
R715 VGND.n715 VGND.n714 585
R716 VGND.n247 VGND.n244 585
R717 VGND.n248 VGND.n247 585
R718 VGND.n709 VGND.n708 585
R719 VGND.n710 VGND.n709 585
R720 VGND.n260 VGND.n251 585
R721 VGND.n251 VGND.n250 585
R722 VGND.n699 VGND.n698 585
R723 VGND.n698 VGND.n697 585
R724 VGND.n261 VGND.n258 585
R725 VGND.n262 VGND.n261 585
R726 VGND.n692 VGND.n691 585
R727 VGND.n693 VGND.n692 585
R728 VGND.n277 VGND.n265 585
R729 VGND.n265 VGND.n264 585
R730 VGND.n683 VGND.n682 585
R731 VGND.n682 VGND.n681 585
R732 VGND.n278 VGND.n275 585
R733 VGND.n279 VGND.n278 585
R734 VGND.n676 VGND.n675 585
R735 VGND.n677 VGND.n676 585
R736 VGND.n291 VGND.n282 585
R737 VGND.n282 VGND.n281 585
R738 VGND.n666 VGND.n665 585
R739 VGND.n665 VGND.n664 585
R740 VGND.n292 VGND.n289 585
R741 VGND.n293 VGND.n292 585
R742 VGND.n659 VGND.n658 585
R743 VGND.n660 VGND.n659 585
R744 VGND.n297 VGND.n296 585
R745 VGND.n296 VGND.n295 585
R746 VGND.n638 VGND.n637 585
R747 VGND.n637 VGND.n636 585
R748 VGND.n306 VGND.n304 585
R749 VGND.n307 VGND.n306 585
R750 VGND.n631 VGND.n630 585
R751 VGND.n632 VGND.n631 585
R752 VGND.n311 VGND.n310 585
R753 VGND.n310 VGND.n309 585
R754 VGND.n620 VGND.n619 585
R755 VGND.n619 VGND.n618 585
R756 VGND.n320 VGND.n318 585
R757 VGND.n321 VGND.n320 585
R758 VGND.n613 VGND.n612 585
R759 VGND.n614 VGND.n613 585
R760 VGND.n612 VGND.n611 585
R761 VGND.n611 VGND.n610 585
R762 VGND.n318 VGND.n317 585
R763 VGND.n317 VGND.n316 585
R764 VGND.n621 VGND.n620 585
R765 VGND.n622 VGND.n621 585
R766 VGND.n313 VGND.n311 585
R767 VGND.n314 VGND.n313 585
R768 VGND.n630 VGND.n629 585
R769 VGND.n629 VGND.n628 585
R770 VGND.n304 VGND.n303 585
R771 VGND.n303 VGND.n302 585
R772 VGND.n639 VGND.n638 585
R773 VGND.n640 VGND.n639 585
R774 VGND.n299 VGND.n297 585
R775 VGND.n300 VGND.n299 585
R776 VGND.n658 VGND.n657 585
R777 VGND.n657 VGND.n656 585
R778 VGND.n289 VGND.n288 585
R779 VGND.n288 VGND.n287 585
R780 VGND.n667 VGND.n666 585
R781 VGND.n668 VGND.n667 585
R782 VGND.n291 VGND.n284 585
R783 VGND.n285 VGND.n284 585
R784 VGND.n675 VGND.n674 585
R785 VGND.n674 VGND.n673 585
R786 VGND.n275 VGND.n274 585
R787 VGND.n274 VGND.n273 585
R788 VGND.n684 VGND.n683 585
R789 VGND.n685 VGND.n684 585
R790 VGND.n277 VGND.n267 585
R791 VGND.n268 VGND.n267 585
R792 VGND.n691 VGND.n690 585
R793 VGND.n690 VGND.n689 585
R794 VGND.n258 VGND.n257 585
R795 VGND.n257 VGND.n256 585
R796 VGND.n700 VGND.n699 585
R797 VGND.n701 VGND.n700 585
R798 VGND.n260 VGND.n253 585
R799 VGND.n254 VGND.n253 585
R800 VGND.n708 VGND.n707 585
R801 VGND.n707 VGND.n706 585
R802 VGND.n244 VGND.n243 585
R803 VGND.n243 VGND.n242 585
R804 VGND.n717 VGND.n716 585
R805 VGND.n718 VGND.n717 585
R806 VGND.n246 VGND.n236 585
R807 VGND.n237 VGND.n236 585
R808 VGND.n724 VGND.n723 585
R809 VGND.n723 VGND.n722 585
R810 VGND.n227 VGND.n226 585
R811 VGND.n226 VGND.n225 585
R812 VGND.n733 VGND.n732 585
R813 VGND.n734 VGND.n733 585
R814 VGND.n229 VGND.n222 585
R815 VGND.n223 VGND.n222 585
R816 VGND.n741 VGND.n740 585
R817 VGND.n740 VGND.n739 585
R818 VGND.n213 VGND.n212 585
R819 VGND.n212 VGND.n211 585
R820 VGND.n750 VGND.n749 585
R821 VGND.n751 VGND.n750 585
R822 VGND.n215 VGND.n205 585
R823 VGND.n206 VGND.n205 585
R824 VGND.n757 VGND.n756 585
R825 VGND.n756 VGND.n755 585
R826 VGND.n197 VGND.n196 585
R827 VGND.n196 VGND.n195 585
R828 VGND.n766 VGND.n765 585
R829 VGND.n767 VGND.n766 585
R830 VGND.n192 VGND.n190 585
R831 VGND.n193 VGND.n192 585
R832 VGND.n773 VGND.n772 585
R833 VGND.n772 VGND.n771 585
R834 VGND.n183 VGND.n182 585
R835 VGND.n182 VGND.n181 585
R836 VGND.n782 VGND.n781 585
R837 VGND.n783 VGND.n782 585
R838 VGND.n178 VGND.n176 585
R839 VGND.n179 VGND.n178 585
R840 VGND.n793 VGND.n792 585
R841 VGND.n792 VGND.n791 585
R842 VGND.n169 VGND.n168 585
R843 VGND.n168 VGND.n167 585
R844 VGND.n802 VGND.n801 585
R845 VGND.n803 VGND.n802 585
R846 VGND.n164 VGND.n162 585
R847 VGND.n165 VGND.n164 585
R848 VGND.n809 VGND.n808 585
R849 VGND.n808 VGND.n807 585
R850 VGND.n155 VGND.n154 585
R851 VGND.n154 VGND.n153 585
R852 VGND.n818 VGND.n817 585
R853 VGND.n819 VGND.n818 585
R854 VGND.n150 VGND.n148 585
R855 VGND.n151 VGND.n150 585
R856 VGND.n829 VGND.n828 585
R857 VGND.n828 VGND.n827 585
R858 VGND.n141 VGND.n140 585
R859 VGND.n140 VGND.n139 585
R860 VGND.n838 VGND.n837 585
R861 VGND.n839 VGND.n838 585
R862 VGND.n136 VGND.n134 585
R863 VGND.n137 VGND.n136 585
R864 VGND.n857 VGND.n856 585
R865 VGND.n856 VGND.n855 585
R866 VGND.n127 VGND.n126 585
R867 VGND.n126 VGND.n125 585
R868 VGND.n866 VGND.n865 585
R869 VGND.n867 VGND.n866 585
R870 VGND.n120 VGND.n118 585
R871 VGND.n122 VGND.n120 585
R872 VGND.n879 VGND.n878 585
R873 VGND.n878 VGND.n877 585
R874 VGND.n121 VGND.n111 585
R875 VGND.n123 VGND.n121 585
R876 VGND.n887 VGND.n112 585
R877 VGND.n873 VGND.n112 585
R878 VGND.n6 VGND.n5 585
R879 VGND.n5 VGND.n4 585
R880 VGND.n944 VGND.n943 585
R881 VGND.n945 VGND.n944 585
R882 VGND.n327 VGND.n325 585
R883 VGND.n328 VGND.n327 585
R884 VGND.n606 VGND.n605 585
R885 VGND.n603 VGND.n330 585
R886 VGND.n602 VGND.n601 585
R887 VGND.n595 VGND.n332 585
R888 VGND.n596 VGND.n325 585
R889 VGND.n597 VGND.n596 585
R890 VGND.n594 VGND.n334 585
R891 VGND.n592 VGND.n591 585
R892 VGND.n335 VGND.n325 585
R893 VGND.n336 VGND.n335 585
R894 VGND.n587 VGND.n586 585
R895 VGND.n584 VGND.n338 585
R896 VGND.n583 VGND.n582 453.957
R897 VGND.n73 VGND.n72 453.957
R898 VGND.n74 VGND.n73 428.262
R899 VGND.n584 VGND.n583 428.262
R900 VGND.n942 VGND.n9 308.349
R901 VGND.n886 VGND.n9 308.349
R902 VGND.n886 VGND.n113 308.349
R903 VGND.n880 VGND.n113 308.349
R904 VGND.n880 VGND.n117 308.349
R905 VGND.n864 VGND.n117 308.349
R906 VGND.n864 VGND.n129 308.349
R907 VGND.n858 VGND.n129 308.349
R908 VGND.n858 VGND.n133 308.349
R909 VGND.n836 VGND.n133 308.349
R910 VGND.n836 VGND.n143 308.349
R911 VGND.n830 VGND.n143 308.349
R912 VGND.n830 VGND.n147 308.349
R913 VGND.n816 VGND.n147 308.349
R914 VGND.n816 VGND.n157 308.349
R915 VGND.n810 VGND.n157 308.349
R916 VGND.n810 VGND.n161 308.349
R917 VGND.n800 VGND.n161 308.349
R918 VGND.n800 VGND.n171 308.349
R919 VGND.n794 VGND.n171 308.349
R920 VGND.n794 VGND.n175 308.349
R921 VGND.n780 VGND.n175 308.349
R922 VGND.n780 VGND.n185 308.349
R923 VGND.n774 VGND.n185 308.349
R924 VGND.n774 VGND.n189 308.349
R925 VGND.n764 VGND.n189 308.349
R926 VGND.n764 VGND.n199 308.349
R927 VGND.n758 VGND.n199 308.349
R928 VGND.n758 VGND.n203 308.349
R929 VGND.n748 VGND.n203 308.349
R930 VGND.n748 VGND.n216 308.349
R931 VGND.n742 VGND.n216 308.349
R932 VGND.n742 VGND.n220 308.349
R933 VGND.n731 VGND.n220 308.349
R934 VGND.n731 VGND.n230 308.349
R935 VGND.n725 VGND.n230 308.349
R936 VGND.n725 VGND.n234 308.349
R937 VGND.n715 VGND.n234 308.349
R938 VGND.n715 VGND.n247 308.349
R939 VGND.n709 VGND.n247 308.349
R940 VGND.n709 VGND.n251 308.349
R941 VGND.n698 VGND.n251 308.349
R942 VGND.n698 VGND.n261 308.349
R943 VGND.n692 VGND.n261 308.349
R944 VGND.n692 VGND.n265 308.349
R945 VGND.n682 VGND.n265 308.349
R946 VGND.n682 VGND.n278 308.349
R947 VGND.n676 VGND.n278 308.349
R948 VGND.n676 VGND.n282 308.349
R949 VGND.n665 VGND.n282 308.349
R950 VGND.n665 VGND.n292 308.349
R951 VGND.n659 VGND.n292 308.349
R952 VGND.n659 VGND.n296 308.349
R953 VGND.n637 VGND.n296 308.349
R954 VGND.n637 VGND.n306 308.349
R955 VGND.n631 VGND.n306 308.349
R956 VGND.n631 VGND.n310 308.349
R957 VGND.n619 VGND.n310 308.349
R958 VGND.n619 VGND.n320 308.349
R959 VGND.n613 VGND.n320 308.349
R960 VGND.n433 VGND.n344 308.349
R961 VGND.n431 VGND.n430 308.349
R962 VGND.n424 VGND.n423 308.349
R963 VGND.n424 VGND.n422 308.349
R964 VGND.n420 VGND.n349 308.349
R965 VGND.n414 VGND.n412 308.349
R966 VGND.n410 VGND.n353 308.349
R967 VGND.n404 VGND.n402 308.349
R968 VGND.n400 VGND.n357 308.349
R969 VGND.n394 VGND.n357 308.349
R970 VGND.n392 VGND.n391 308.349
R971 VGND.n385 VGND.n384 308.349
R972 VGND.n382 VGND.n381 308.349
R973 VGND.n381 VGND.n365 308.349
R974 VGND.n375 VGND.n373 308.349
R975 VGND.n371 VGND.n324 308.349
R976 VGND.n110 VGND.n7 308.349
R977 VGND.n888 VGND.n110 308.349
R978 VGND.n888 VGND.n109 308.349
R979 VGND.n119 VGND.n109 308.349
R980 VGND.n491 VGND.n119 308.349
R981 VGND.n491 VGND.n128 308.349
R982 VGND.n490 VGND.n128 308.349
R983 VGND.n490 VGND.n135 308.349
R984 VGND.n487 VGND.n135 308.349
R985 VGND.n487 VGND.n142 308.349
R986 VGND.n486 VGND.n142 308.349
R987 VGND.n486 VGND.n149 308.349
R988 VGND.n483 VGND.n149 308.349
R989 VGND.n483 VGND.n156 308.349
R990 VGND.n482 VGND.n156 308.349
R991 VGND.n482 VGND.n163 308.349
R992 VGND.n479 VGND.n163 308.349
R993 VGND.n479 VGND.n170 308.349
R994 VGND.n478 VGND.n170 308.349
R995 VGND.n478 VGND.n177 308.349
R996 VGND.n475 VGND.n177 308.349
R997 VGND.n475 VGND.n184 308.349
R998 VGND.n474 VGND.n184 308.349
R999 VGND.n474 VGND.n191 308.349
R1000 VGND.n471 VGND.n191 308.349
R1001 VGND.n471 VGND.n198 308.349
R1002 VGND.n470 VGND.n198 308.349
R1003 VGND.n470 VGND.n204 308.349
R1004 VGND.n467 VGND.n204 308.349
R1005 VGND.n467 VGND.n214 308.349
R1006 VGND.n466 VGND.n214 308.349
R1007 VGND.n466 VGND.n221 308.349
R1008 VGND.n463 VGND.n221 308.349
R1009 VGND.n463 VGND.n228 308.349
R1010 VGND.n462 VGND.n228 308.349
R1011 VGND.n462 VGND.n235 308.349
R1012 VGND.n459 VGND.n235 308.349
R1013 VGND.n459 VGND.n245 308.349
R1014 VGND.n458 VGND.n245 308.349
R1015 VGND.n458 VGND.n252 308.349
R1016 VGND.n455 VGND.n252 308.349
R1017 VGND.n455 VGND.n259 308.349
R1018 VGND.n454 VGND.n259 308.349
R1019 VGND.n454 VGND.n266 308.349
R1020 VGND.n451 VGND.n266 308.349
R1021 VGND.n451 VGND.n276 308.349
R1022 VGND.n450 VGND.n276 308.349
R1023 VGND.n450 VGND.n283 308.349
R1024 VGND.n447 VGND.n283 308.349
R1025 VGND.n447 VGND.n290 308.349
R1026 VGND.n446 VGND.n290 308.349
R1027 VGND.n446 VGND.n298 308.349
R1028 VGND.n443 VGND.n298 308.349
R1029 VGND.n443 VGND.n305 308.349
R1030 VGND.n442 VGND.n305 308.349
R1031 VGND.n442 VGND.n312 308.349
R1032 VGND.n439 VGND.n312 308.349
R1033 VGND.n439 VGND.n319 308.349
R1034 VGND.n438 VGND.n319 308.349
R1035 VGND.n438 VGND.n326 308.349
R1036 VGND.n91 VGND.n90 308.349
R1037 VGND.n87 VGND.n86 308.349
R1038 VGND.n86 VGND.n85 308.349
R1039 VGND.n81 VGND.n80 308.349
R1040 VGND.n80 VGND.n79 308.349
R1041 VGND.n77 VGND.n74 308.349
R1042 VGND.n70 VGND.n67 308.349
R1043 VGND.n65 VGND.n64 308.349
R1044 VGND.n62 VGND.n59 308.349
R1045 VGND.n57 VGND.n56 308.349
R1046 VGND.n54 VGND.n51 308.349
R1047 VGND.n49 VGND.n48 308.349
R1048 VGND.n46 VGND.n43 308.349
R1049 VGND.n41 VGND.n40 308.349
R1050 VGND.n38 VGND.n35 308.349
R1051 VGND.n33 VGND.n32 308.349
R1052 VGND.n30 VGND.n27 308.349
R1053 VGND.n25 VGND.n24 308.349
R1054 VGND.n22 VGND.n19 308.349
R1055 VGND.n17 VGND.n16 308.349
R1056 VGND.n944 VGND.n5 308.349
R1057 VGND.n112 VGND.n5 308.349
R1058 VGND.n121 VGND.n112 308.349
R1059 VGND.n878 VGND.n121 308.349
R1060 VGND.n878 VGND.n120 308.349
R1061 VGND.n866 VGND.n120 308.349
R1062 VGND.n866 VGND.n126 308.349
R1063 VGND.n856 VGND.n126 308.349
R1064 VGND.n856 VGND.n136 308.349
R1065 VGND.n838 VGND.n136 308.349
R1066 VGND.n838 VGND.n140 308.349
R1067 VGND.n828 VGND.n140 308.349
R1068 VGND.n828 VGND.n150 308.349
R1069 VGND.n818 VGND.n150 308.349
R1070 VGND.n818 VGND.n154 308.349
R1071 VGND.n808 VGND.n154 308.349
R1072 VGND.n808 VGND.n164 308.349
R1073 VGND.n802 VGND.n164 308.349
R1074 VGND.n802 VGND.n168 308.349
R1075 VGND.n792 VGND.n168 308.349
R1076 VGND.n792 VGND.n178 308.349
R1077 VGND.n782 VGND.n178 308.349
R1078 VGND.n782 VGND.n182 308.349
R1079 VGND.n772 VGND.n182 308.349
R1080 VGND.n772 VGND.n192 308.349
R1081 VGND.n766 VGND.n192 308.349
R1082 VGND.n766 VGND.n196 308.349
R1083 VGND.n756 VGND.n196 308.349
R1084 VGND.n756 VGND.n205 308.349
R1085 VGND.n750 VGND.n205 308.349
R1086 VGND.n750 VGND.n212 308.349
R1087 VGND.n740 VGND.n212 308.349
R1088 VGND.n740 VGND.n222 308.349
R1089 VGND.n733 VGND.n222 308.349
R1090 VGND.n733 VGND.n226 308.349
R1091 VGND.n723 VGND.n226 308.349
R1092 VGND.n723 VGND.n236 308.349
R1093 VGND.n717 VGND.n236 308.349
R1094 VGND.n717 VGND.n243 308.349
R1095 VGND.n707 VGND.n243 308.349
R1096 VGND.n707 VGND.n253 308.349
R1097 VGND.n700 VGND.n253 308.349
R1098 VGND.n700 VGND.n257 308.349
R1099 VGND.n690 VGND.n257 308.349
R1100 VGND.n690 VGND.n267 308.349
R1101 VGND.n684 VGND.n267 308.349
R1102 VGND.n684 VGND.n274 308.349
R1103 VGND.n674 VGND.n274 308.349
R1104 VGND.n674 VGND.n284 308.349
R1105 VGND.n667 VGND.n284 308.349
R1106 VGND.n667 VGND.n288 308.349
R1107 VGND.n657 VGND.n288 308.349
R1108 VGND.n657 VGND.n299 308.349
R1109 VGND.n639 VGND.n299 308.349
R1110 VGND.n639 VGND.n303 308.349
R1111 VGND.n629 VGND.n303 308.349
R1112 VGND.n629 VGND.n313 308.349
R1113 VGND.n621 VGND.n313 308.349
R1114 VGND.n621 VGND.n317 308.349
R1115 VGND.n611 VGND.n317 308.349
R1116 VGND.n605 VGND.n327 308.349
R1117 VGND.n603 VGND.n602 308.349
R1118 VGND.n596 VGND.n595 308.349
R1119 VGND.n596 VGND.n594 308.349
R1120 VGND.n592 VGND.n335 308.349
R1121 VGND.n586 VGND.n335 308.349
R1122 VGND.n73 VGND.n7 269.805
R1123 VGND.n583 VGND.n326 269.805
R1124 VGND.n339 VGND.n325 231.493
R1125 VGND.n432 VGND.n325 231.493
R1126 VGND.n345 VGND.n325 231.493
R1127 VGND.n421 VGND.n325 231.493
R1128 VGND.n413 VGND.n325 231.493
R1129 VGND.n411 VGND.n325 231.493
R1130 VGND.n403 VGND.n325 231.493
R1131 VGND.n401 VGND.n325 231.493
R1132 VGND.n393 VGND.n325 231.493
R1133 VGND.n361 VGND.n325 231.493
R1134 VGND.n383 VGND.n325 231.493
R1135 VGND.n374 VGND.n325 231.493
R1136 VGND.n372 VGND.n325 231.493
R1137 VGND.n78 VGND.n8 231.493
R1138 VGND.n84 VGND.n8 231.493
R1139 VGND.n88 VGND.n8 231.493
R1140 VGND.n89 VGND.n8 231.493
R1141 VGND.n15 VGND.n8 231.493
R1142 VGND.n18 VGND.n8 231.493
R1143 VGND.n23 VGND.n8 231.493
R1144 VGND.n26 VGND.n8 231.493
R1145 VGND.n31 VGND.n8 231.493
R1146 VGND.n34 VGND.n8 231.493
R1147 VGND.n39 VGND.n8 231.493
R1148 VGND.n42 VGND.n8 231.493
R1149 VGND.n47 VGND.n8 231.493
R1150 VGND.n50 VGND.n8 231.493
R1151 VGND.n55 VGND.n8 231.493
R1152 VGND.n58 VGND.n8 231.493
R1153 VGND.n63 VGND.n8 231.493
R1154 VGND.n66 VGND.n8 231.493
R1155 VGND.n71 VGND.n8 231.493
R1156 VGND.n604 VGND.n325 231.493
R1157 VGND.n331 VGND.n325 231.493
R1158 VGND.n593 VGND.n325 231.493
R1159 VGND.n585 VGND.n325 231.493
R1160 VGND.n625 VGND.t38 130.113
R1161 VGND.n869 VGND.t30 130.113
R1162 VGND.n625 VGND.t50 129.377
R1163 VGND.n869 VGND.t42 129.377
R1164 VGND.n344 VGND.n339 122.017
R1165 VGND.n433 VGND.n432 122.017
R1166 VGND.n423 VGND.n345 122.017
R1167 VGND.n421 VGND.n420 122.017
R1168 VGND.n414 VGND.n413 122.017
R1169 VGND.n411 VGND.n410 122.017
R1170 VGND.n403 VGND.n353 122.017
R1171 VGND.n401 VGND.n400 122.017
R1172 VGND.n393 VGND.n392 122.017
R1173 VGND.n384 VGND.n361 122.017
R1174 VGND.n383 VGND.n382 122.017
R1175 VGND.n374 VGND.n365 122.017
R1176 VGND.n372 VGND.n371 122.017
R1177 VGND.n78 VGND.n77 122.017
R1178 VGND.n84 VGND.n81 122.017
R1179 VGND.n88 VGND.n87 122.017
R1180 VGND.n89 VGND.n3 122.017
R1181 VGND.n15 VGND.n10 122.017
R1182 VGND.n18 VGND.n17 122.017
R1183 VGND.n23 VGND.n22 122.017
R1184 VGND.n26 VGND.n25 122.017
R1185 VGND.n31 VGND.n30 122.017
R1186 VGND.n34 VGND.n33 122.017
R1187 VGND.n39 VGND.n38 122.017
R1188 VGND.n42 VGND.n41 122.017
R1189 VGND.n47 VGND.n46 122.017
R1190 VGND.n50 VGND.n49 122.017
R1191 VGND.n55 VGND.n54 122.017
R1192 VGND.n58 VGND.n57 122.017
R1193 VGND.n63 VGND.n62 122.017
R1194 VGND.n66 VGND.n65 122.017
R1195 VGND.n71 VGND.n70 122.017
R1196 VGND.n582 VGND.n339 122.017
R1197 VGND.n432 VGND.n431 122.017
R1198 VGND.n430 VGND.n345 122.017
R1199 VGND.n422 VGND.n421 122.017
R1200 VGND.n413 VGND.n349 122.017
R1201 VGND.n412 VGND.n411 122.017
R1202 VGND.n404 VGND.n403 122.017
R1203 VGND.n402 VGND.n401 122.017
R1204 VGND.n394 VGND.n393 122.017
R1205 VGND.n391 VGND.n361 122.017
R1206 VGND.n385 VGND.n383 122.017
R1207 VGND.n375 VGND.n374 122.017
R1208 VGND.n373 VGND.n372 122.017
R1209 VGND.n90 VGND.n89 122.017
R1210 VGND.n91 VGND.n88 122.017
R1211 VGND.n85 VGND.n84 122.017
R1212 VGND.n79 VGND.n78 122.017
R1213 VGND.n72 VGND.n71 122.017
R1214 VGND.n67 VGND.n66 122.017
R1215 VGND.n64 VGND.n63 122.017
R1216 VGND.n59 VGND.n58 122.017
R1217 VGND.n56 VGND.n55 122.017
R1218 VGND.n51 VGND.n50 122.017
R1219 VGND.n48 VGND.n47 122.017
R1220 VGND.n43 VGND.n42 122.017
R1221 VGND.n40 VGND.n39 122.017
R1222 VGND.n35 VGND.n34 122.017
R1223 VGND.n32 VGND.n31 122.017
R1224 VGND.n27 VGND.n26 122.017
R1225 VGND.n24 VGND.n23 122.017
R1226 VGND.n19 VGND.n18 122.017
R1227 VGND.n16 VGND.n15 122.017
R1228 VGND.n604 VGND.n603 122.017
R1229 VGND.n595 VGND.n331 122.017
R1230 VGND.n593 VGND.n592 122.017
R1231 VGND.n586 VGND.n585 122.017
R1232 VGND.n605 VGND.n604 122.017
R1233 VGND.n602 VGND.n331 122.017
R1234 VGND.n594 VGND.n593 122.017
R1235 VGND.n585 VGND.n584 122.017
R1236 VGND.n271 VGND.n269 100.112
R1237 VGND.n240 VGND.n238 100.112
R1238 VGND.n209 VGND.n207 100.112
R1239 VGND.n787 VGND.n785 100.112
R1240 VGND.n823 VGND.n821 100.112
R1241 VGND.n271 VGND.n270 99.3773
R1242 VGND.n240 VGND.n239 99.3773
R1243 VGND.n209 VGND.n208 99.3773
R1244 VGND.n787 VGND.n786 99.3773
R1245 VGND.n823 VGND.n822 99.3773
R1246 VGND.n645 VGND.n644 97.1476
R1247 VGND.n843 VGND.n842 97.1476
R1248 VGND.n943 VGND.n6 92.9037
R1249 VGND.n887 VGND.n6 92.9037
R1250 VGND.n887 VGND.n111 92.9037
R1251 VGND.n879 VGND.n111 92.9037
R1252 VGND.n879 VGND.n118 92.9037
R1253 VGND.n865 VGND.n118 92.9037
R1254 VGND.n865 VGND.n127 92.9037
R1255 VGND.n857 VGND.n134 92.9037
R1256 VGND.n837 VGND.n134 92.9037
R1257 VGND.n837 VGND.n141 92.9037
R1258 VGND.n829 VGND.n148 92.9037
R1259 VGND.n817 VGND.n148 92.9037
R1260 VGND.n817 VGND.n155 92.9037
R1261 VGND.n809 VGND.n162 92.9037
R1262 VGND.n801 VGND.n162 92.9037
R1263 VGND.n801 VGND.n169 92.9037
R1264 VGND.n793 VGND.n176 92.9037
R1265 VGND.n781 VGND.n176 92.9037
R1266 VGND.n781 VGND.n183 92.9037
R1267 VGND.n773 VGND.n190 92.9037
R1268 VGND.n765 VGND.n190 92.9037
R1269 VGND.n765 VGND.n197 92.9037
R1270 VGND.n757 VGND.n197 92.9037
R1271 VGND.n749 VGND.n215 92.9037
R1272 VGND.n749 VGND.n213 92.9037
R1273 VGND.n741 VGND.n213 92.9037
R1274 VGND.n732 VGND.n229 92.9037
R1275 VGND.n732 VGND.n227 92.9037
R1276 VGND.n724 VGND.n227 92.9037
R1277 VGND.n716 VGND.n246 92.9037
R1278 VGND.n716 VGND.n244 92.9037
R1279 VGND.n708 VGND.n244 92.9037
R1280 VGND.n699 VGND.n260 92.9037
R1281 VGND.n699 VGND.n258 92.9037
R1282 VGND.n691 VGND.n258 92.9037
R1283 VGND.n683 VGND.n277 92.9037
R1284 VGND.n683 VGND.n275 92.9037
R1285 VGND.n675 VGND.n275 92.9037
R1286 VGND.n666 VGND.n291 92.9037
R1287 VGND.n666 VGND.n289 92.9037
R1288 VGND.n658 VGND.n289 92.9037
R1289 VGND.n658 VGND.n297 92.9037
R1290 VGND.n638 VGND.n304 92.9037
R1291 VGND.n630 VGND.n304 92.9037
R1292 VGND.n630 VGND.n311 92.9037
R1293 VGND.n620 VGND.n311 92.9037
R1294 VGND.n620 VGND.n318 92.9037
R1295 VGND.n612 VGND.n318 92.9037
R1296 VGND.n651 VGND.n650 86.1871
R1297 VGND.n849 VGND.n848 86.1871
R1298 VGND.t6 VGND.n183 85.1618
R1299 VGND.n215 VGND.t7 85.1618
R1300 VGND.n675 VGND.t2 85.1618
R1301 VGND.n638 VGND.t3 85.1618
R1302 VGND.n648 VGND.t49 84.9593
R1303 VGND.n643 VGND.t37 84.9593
R1304 VGND.n846 VGND.t43 84.9569
R1305 VGND.n841 VGND.t31 84.9569
R1306 VGND.n846 VGND.t40 84.9533
R1307 VGND.n841 VGND.t28 84.9533
R1308 VGND.n648 VGND.t46 84.9508
R1309 VGND.n643 VGND.t34 84.9508
R1310 VGND.n943 VGND.n8 81.2908
R1311 VGND.n612 VGND.n325 81.2908
R1312 VGND.n857 VGND.t8 69.6779
R1313 VGND.t10 VGND.n169 69.6779
R1314 VGND.n229 VGND.t11 69.6779
R1315 VGND.n691 VGND.t1 69.6779
R1316 VGND.n829 VGND.t5 54.194
R1317 VGND.t9 VGND.n155 54.194
R1318 VGND.n246 VGND.t4 54.194
R1319 VGND.n708 VGND.t0 54.194
R1320 VGND.n941 VGND.n12 47.0266
R1321 VGND.n614 VGND.n323 47.0266
R1322 VGND.n946 VGND.n945 45.357
R1323 VGND.n610 VGND.n328 45.357
R1324 VGND.t5 VGND.n141 38.7102
R1325 VGND.n809 VGND.t9 38.7102
R1326 VGND.n724 VGND.t4 38.7102
R1327 VGND.n260 VGND.t0 38.7102
R1328 VGND.n650 VGND.t47 30.0005
R1329 VGND.n650 VGND.t51 30.0005
R1330 VGND.n644 VGND.t35 30.0005
R1331 VGND.n644 VGND.t39 30.0005
R1332 VGND.n270 VGND.t27 30.0005
R1333 VGND.n270 VGND.t48 30.0005
R1334 VGND.n269 VGND.t12 30.0005
R1335 VGND.n269 VGND.t36 30.0005
R1336 VGND.n239 VGND.t25 30.0005
R1337 VGND.n239 VGND.t26 30.0005
R1338 VGND.n238 VGND.t20 30.0005
R1339 VGND.n238 VGND.t18 30.0005
R1340 VGND.n208 VGND.t23 30.0005
R1341 VGND.n208 VGND.t24 30.0005
R1342 VGND.n207 VGND.t17 30.0005
R1343 VGND.n207 VGND.t19 30.0005
R1344 VGND.n786 VGND.t21 30.0005
R1345 VGND.n786 VGND.t22 30.0005
R1346 VGND.n785 VGND.t15 30.0005
R1347 VGND.n785 VGND.t16 30.0005
R1348 VGND.n822 VGND.t44 30.0005
R1349 VGND.n822 VGND.t13 30.0005
R1350 VGND.n821 VGND.t32 30.0005
R1351 VGND.n821 VGND.t14 30.0005
R1352 VGND.n848 VGND.t41 30.0005
R1353 VGND.n848 VGND.t45 30.0005
R1354 VGND.n842 VGND.t29 30.0005
R1355 VGND.n842 VGND.t33 30.0005
R1356 VGND.n581 VGND.n341 29.4962
R1357 VGND.n895 VGND.n894 29.4962
R1358 VGND.n894 VGND.n105 27.8266
R1359 VGND.n341 VGND.n338 27.8266
R1360 VGND.t8 VGND.n127 23.2263
R1361 VGND.n793 VGND.t10 23.2263
R1362 VGND.n741 VGND.t11 23.2263
R1363 VGND.n277 VGND.t1 23.2263
R1364 VGND.n651 VGND.n649 21.9288
R1365 VGND.n652 VGND.n651 21.9288
R1366 VGND.n849 VGND.n847 21.9288
R1367 VGND.n850 VGND.n849 21.9288
R1368 VGND.n581 VGND.n340 20.0353
R1369 VGND.n434 VGND.n340 20.0353
R1370 VGND.n434 VGND.n343 20.0353
R1371 VGND.n429 VGND.n343 20.0353
R1372 VGND.n429 VGND.n346 20.0353
R1373 VGND.n425 VGND.n346 20.0353
R1374 VGND.n425 VGND.n348 20.0353
R1375 VGND.n419 VGND.n348 20.0353
R1376 VGND.n419 VGND.n350 20.0353
R1377 VGND.n415 VGND.n350 20.0353
R1378 VGND.n415 VGND.n352 20.0353
R1379 VGND.n409 VGND.n352 20.0353
R1380 VGND.n409 VGND.n354 20.0353
R1381 VGND.n405 VGND.n354 20.0353
R1382 VGND.n405 VGND.n356 20.0353
R1383 VGND.n399 VGND.n356 20.0353
R1384 VGND.n399 VGND.n358 20.0353
R1385 VGND.n395 VGND.n358 20.0353
R1386 VGND.n395 VGND.n360 20.0353
R1387 VGND.n390 VGND.n360 20.0353
R1388 VGND.n390 VGND.n362 20.0353
R1389 VGND.n386 VGND.n362 20.0353
R1390 VGND.n386 VGND.n364 20.0353
R1391 VGND.n380 VGND.n364 20.0353
R1392 VGND.n380 VGND.n366 20.0353
R1393 VGND.n376 VGND.n366 20.0353
R1394 VGND.n376 VGND.n368 20.0353
R1395 VGND.n370 VGND.n368 20.0353
R1396 VGND.n370 VGND.n323 20.0353
R1397 VGND.n893 VGND.n106 20.0353
R1398 VGND.n889 VGND.n106 20.0353
R1399 VGND.n889 VGND.n108 20.0353
R1400 VGND.n493 VGND.n108 20.0353
R1401 VGND.n493 VGND.n492 20.0353
R1402 VGND.n497 VGND.n492 20.0353
R1403 VGND.n498 VGND.n497 20.0353
R1404 VGND.n499 VGND.n498 20.0353
R1405 VGND.n499 VGND.n488 20.0353
R1406 VGND.n503 VGND.n488 20.0353
R1407 VGND.n504 VGND.n503 20.0353
R1408 VGND.n505 VGND.n504 20.0353
R1409 VGND.n505 VGND.n484 20.0353
R1410 VGND.n509 VGND.n484 20.0353
R1411 VGND.n510 VGND.n509 20.0353
R1412 VGND.n511 VGND.n510 20.0353
R1413 VGND.n511 VGND.n480 20.0353
R1414 VGND.n515 VGND.n480 20.0353
R1415 VGND.n516 VGND.n515 20.0353
R1416 VGND.n517 VGND.n516 20.0353
R1417 VGND.n517 VGND.n476 20.0353
R1418 VGND.n521 VGND.n476 20.0353
R1419 VGND.n522 VGND.n521 20.0353
R1420 VGND.n523 VGND.n522 20.0353
R1421 VGND.n523 VGND.n472 20.0353
R1422 VGND.n527 VGND.n472 20.0353
R1423 VGND.n528 VGND.n527 20.0353
R1424 VGND.n529 VGND.n528 20.0353
R1425 VGND.n529 VGND.n468 20.0353
R1426 VGND.n533 VGND.n468 20.0353
R1427 VGND.n534 VGND.n533 20.0353
R1428 VGND.n535 VGND.n534 20.0353
R1429 VGND.n535 VGND.n464 20.0353
R1430 VGND.n539 VGND.n464 20.0353
R1431 VGND.n540 VGND.n539 20.0353
R1432 VGND.n541 VGND.n540 20.0353
R1433 VGND.n541 VGND.n460 20.0353
R1434 VGND.n545 VGND.n460 20.0353
R1435 VGND.n546 VGND.n545 20.0353
R1436 VGND.n547 VGND.n546 20.0353
R1437 VGND.n547 VGND.n456 20.0353
R1438 VGND.n551 VGND.n456 20.0353
R1439 VGND.n552 VGND.n551 20.0353
R1440 VGND.n553 VGND.n552 20.0353
R1441 VGND.n553 VGND.n452 20.0353
R1442 VGND.n557 VGND.n452 20.0353
R1443 VGND.n558 VGND.n557 20.0353
R1444 VGND.n559 VGND.n558 20.0353
R1445 VGND.n559 VGND.n448 20.0353
R1446 VGND.n563 VGND.n448 20.0353
R1447 VGND.n564 VGND.n563 20.0353
R1448 VGND.n565 VGND.n564 20.0353
R1449 VGND.n565 VGND.n444 20.0353
R1450 VGND.n569 VGND.n444 20.0353
R1451 VGND.n570 VGND.n569 20.0353
R1452 VGND.n571 VGND.n570 20.0353
R1453 VGND.n571 VGND.n440 20.0353
R1454 VGND.n575 VGND.n440 20.0353
R1455 VGND.n576 VGND.n575 20.0353
R1456 VGND.n577 VGND.n576 20.0353
R1457 VGND.n946 VGND.n2 20.0353
R1458 VGND.n93 VGND.n2 20.0353
R1459 VGND.n94 VGND.n93 20.0353
R1460 VGND.n95 VGND.n94 20.0353
R1461 VGND.n95 VGND.n82 20.0353
R1462 VGND.n99 VGND.n82 20.0353
R1463 VGND.n100 VGND.n99 20.0353
R1464 VGND.n101 VGND.n100 20.0353
R1465 VGND.n101 VGND.n75 20.0353
R1466 VGND.n105 VGND.n75 20.0353
R1467 VGND.n895 VGND.n68 20.0353
R1468 VGND.n899 VGND.n68 20.0353
R1469 VGND.n900 VGND.n899 20.0353
R1470 VGND.n901 VGND.n900 20.0353
R1471 VGND.n901 VGND.n60 20.0353
R1472 VGND.n905 VGND.n60 20.0353
R1473 VGND.n906 VGND.n905 20.0353
R1474 VGND.n907 VGND.n906 20.0353
R1475 VGND.n907 VGND.n52 20.0353
R1476 VGND.n911 VGND.n52 20.0353
R1477 VGND.n912 VGND.n911 20.0353
R1478 VGND.n913 VGND.n912 20.0353
R1479 VGND.n913 VGND.n44 20.0353
R1480 VGND.n917 VGND.n44 20.0353
R1481 VGND.n918 VGND.n917 20.0353
R1482 VGND.n919 VGND.n918 20.0353
R1483 VGND.n919 VGND.n36 20.0353
R1484 VGND.n923 VGND.n36 20.0353
R1485 VGND.n924 VGND.n923 20.0353
R1486 VGND.n925 VGND.n924 20.0353
R1487 VGND.n925 VGND.n28 20.0353
R1488 VGND.n929 VGND.n28 20.0353
R1489 VGND.n930 VGND.n929 20.0353
R1490 VGND.n931 VGND.n930 20.0353
R1491 VGND.n931 VGND.n20 20.0353
R1492 VGND.n935 VGND.n20 20.0353
R1493 VGND.n936 VGND.n935 20.0353
R1494 VGND.n937 VGND.n936 20.0353
R1495 VGND.n937 VGND.n12 20.0353
R1496 VGND.n941 VGND.n11 20.0353
R1497 VGND.n885 VGND.n11 20.0353
R1498 VGND.n885 VGND.n114 20.0353
R1499 VGND.n881 VGND.n114 20.0353
R1500 VGND.n881 VGND.n116 20.0353
R1501 VGND.n863 VGND.n116 20.0353
R1502 VGND.n863 VGND.n130 20.0353
R1503 VGND.n859 VGND.n130 20.0353
R1504 VGND.n859 VGND.n132 20.0353
R1505 VGND.n835 VGND.n132 20.0353
R1506 VGND.n835 VGND.n144 20.0353
R1507 VGND.n831 VGND.n144 20.0353
R1508 VGND.n831 VGND.n146 20.0353
R1509 VGND.n815 VGND.n146 20.0353
R1510 VGND.n815 VGND.n158 20.0353
R1511 VGND.n811 VGND.n158 20.0353
R1512 VGND.n811 VGND.n160 20.0353
R1513 VGND.n799 VGND.n160 20.0353
R1514 VGND.n799 VGND.n172 20.0353
R1515 VGND.n795 VGND.n172 20.0353
R1516 VGND.n795 VGND.n174 20.0353
R1517 VGND.n779 VGND.n174 20.0353
R1518 VGND.n779 VGND.n186 20.0353
R1519 VGND.n775 VGND.n186 20.0353
R1520 VGND.n775 VGND.n188 20.0353
R1521 VGND.n763 VGND.n188 20.0353
R1522 VGND.n763 VGND.n200 20.0353
R1523 VGND.n759 VGND.n200 20.0353
R1524 VGND.n759 VGND.n202 20.0353
R1525 VGND.n747 VGND.n202 20.0353
R1526 VGND.n747 VGND.n217 20.0353
R1527 VGND.n743 VGND.n217 20.0353
R1528 VGND.n743 VGND.n219 20.0353
R1529 VGND.n730 VGND.n219 20.0353
R1530 VGND.n730 VGND.n231 20.0353
R1531 VGND.n726 VGND.n231 20.0353
R1532 VGND.n726 VGND.n233 20.0353
R1533 VGND.n714 VGND.n233 20.0353
R1534 VGND.n714 VGND.n248 20.0353
R1535 VGND.n710 VGND.n248 20.0353
R1536 VGND.n710 VGND.n250 20.0353
R1537 VGND.n697 VGND.n250 20.0353
R1538 VGND.n697 VGND.n262 20.0353
R1539 VGND.n693 VGND.n262 20.0353
R1540 VGND.n693 VGND.n264 20.0353
R1541 VGND.n681 VGND.n264 20.0353
R1542 VGND.n681 VGND.n279 20.0353
R1543 VGND.n677 VGND.n279 20.0353
R1544 VGND.n677 VGND.n281 20.0353
R1545 VGND.n664 VGND.n281 20.0353
R1546 VGND.n664 VGND.n293 20.0353
R1547 VGND.n660 VGND.n293 20.0353
R1548 VGND.n660 VGND.n295 20.0353
R1549 VGND.n636 VGND.n295 20.0353
R1550 VGND.n636 VGND.n307 20.0353
R1551 VGND.n632 VGND.n307 20.0353
R1552 VGND.n632 VGND.n309 20.0353
R1553 VGND.n618 VGND.n309 20.0353
R1554 VGND.n618 VGND.n321 20.0353
R1555 VGND.n614 VGND.n321 20.0353
R1556 VGND.n606 VGND.n328 20.0353
R1557 VGND.n606 VGND.n330 20.0353
R1558 VGND.n601 VGND.n330 20.0353
R1559 VGND.n601 VGND.n332 20.0353
R1560 VGND.n597 VGND.n332 20.0353
R1561 VGND.n597 VGND.n334 20.0353
R1562 VGND.n591 VGND.n334 20.0353
R1563 VGND.n591 VGND.n336 20.0353
R1564 VGND.n587 VGND.n336 20.0353
R1565 VGND.n587 VGND.n338 20.0353
R1566 VGND.n945 VGND.n4 20.0353
R1567 VGND.n873 VGND.n4 20.0353
R1568 VGND.n873 VGND.n123 20.0353
R1569 VGND.n877 VGND.n123 20.0353
R1570 VGND.n877 VGND.n122 20.0353
R1571 VGND.n867 VGND.n122 20.0353
R1572 VGND.n867 VGND.n125 20.0353
R1573 VGND.n855 VGND.n125 20.0353
R1574 VGND.n855 VGND.n137 20.0353
R1575 VGND.n839 VGND.n137 20.0353
R1576 VGND.n839 VGND.n139 20.0353
R1577 VGND.n827 VGND.n139 20.0353
R1578 VGND.n827 VGND.n151 20.0353
R1579 VGND.n819 VGND.n151 20.0353
R1580 VGND.n819 VGND.n153 20.0353
R1581 VGND.n807 VGND.n153 20.0353
R1582 VGND.n807 VGND.n165 20.0353
R1583 VGND.n803 VGND.n165 20.0353
R1584 VGND.n803 VGND.n167 20.0353
R1585 VGND.n791 VGND.n167 20.0353
R1586 VGND.n791 VGND.n179 20.0353
R1587 VGND.n783 VGND.n179 20.0353
R1588 VGND.n783 VGND.n181 20.0353
R1589 VGND.n771 VGND.n181 20.0353
R1590 VGND.n771 VGND.n193 20.0353
R1591 VGND.n767 VGND.n193 20.0353
R1592 VGND.n767 VGND.n195 20.0353
R1593 VGND.n755 VGND.n195 20.0353
R1594 VGND.n755 VGND.n206 20.0353
R1595 VGND.n751 VGND.n206 20.0353
R1596 VGND.n751 VGND.n211 20.0353
R1597 VGND.n739 VGND.n211 20.0353
R1598 VGND.n739 VGND.n223 20.0353
R1599 VGND.n734 VGND.n223 20.0353
R1600 VGND.n734 VGND.n225 20.0353
R1601 VGND.n722 VGND.n225 20.0353
R1602 VGND.n722 VGND.n237 20.0353
R1603 VGND.n718 VGND.n237 20.0353
R1604 VGND.n718 VGND.n242 20.0353
R1605 VGND.n706 VGND.n242 20.0353
R1606 VGND.n706 VGND.n254 20.0353
R1607 VGND.n701 VGND.n254 20.0353
R1608 VGND.n701 VGND.n256 20.0353
R1609 VGND.n689 VGND.n256 20.0353
R1610 VGND.n689 VGND.n268 20.0353
R1611 VGND.n685 VGND.n268 20.0353
R1612 VGND.n685 VGND.n273 20.0353
R1613 VGND.n673 VGND.n273 20.0353
R1614 VGND.n673 VGND.n285 20.0353
R1615 VGND.n668 VGND.n285 20.0353
R1616 VGND.n668 VGND.n287 20.0353
R1617 VGND.n656 VGND.n287 20.0353
R1618 VGND.n656 VGND.n300 20.0353
R1619 VGND.n640 VGND.n300 20.0353
R1620 VGND.n640 VGND.n302 20.0353
R1621 VGND.n628 VGND.n302 20.0353
R1622 VGND.n628 VGND.n314 20.0353
R1623 VGND.n622 VGND.n314 20.0353
R1624 VGND.n622 VGND.n316 20.0353
R1625 VGND.n610 VGND.n316 20.0353
R1626 VGND.n894 VGND.n893 17.5309
R1627 VGND.n577 VGND.n341 17.5309
R1628 VGND.n610 VGND.n609 9.3005
R1629 VGND.n316 VGND.n315 9.3005
R1630 VGND.n623 VGND.n622 9.3005
R1631 VGND.n624 VGND.n314 9.3005
R1632 VGND.n628 VGND.n627 9.3005
R1633 VGND.n302 VGND.n301 9.3005
R1634 VGND.n641 VGND.n640 9.3005
R1635 VGND.n642 VGND.n300 9.3005
R1636 VGND.n656 VGND.n655 9.3005
R1637 VGND.n287 VGND.n286 9.3005
R1638 VGND.n669 VGND.n668 9.3005
R1639 VGND.n670 VGND.n285 9.3005
R1640 VGND.n673 VGND.n672 9.3005
R1641 VGND.n671 VGND.n273 9.3005
R1642 VGND.n686 VGND.n685 9.3005
R1643 VGND.n687 VGND.n268 9.3005
R1644 VGND.n689 VGND.n688 9.3005
R1645 VGND.n256 VGND.n255 9.3005
R1646 VGND.n702 VGND.n701 9.3005
R1647 VGND.n703 VGND.n254 9.3005
R1648 VGND.n706 VGND.n705 9.3005
R1649 VGND.n704 VGND.n242 9.3005
R1650 VGND.n719 VGND.n718 9.3005
R1651 VGND.n720 VGND.n237 9.3005
R1652 VGND.n722 VGND.n721 9.3005
R1653 VGND.n225 VGND.n224 9.3005
R1654 VGND.n735 VGND.n734 9.3005
R1655 VGND.n736 VGND.n223 9.3005
R1656 VGND.n739 VGND.n738 9.3005
R1657 VGND.n737 VGND.n211 9.3005
R1658 VGND.n752 VGND.n751 9.3005
R1659 VGND.n753 VGND.n206 9.3005
R1660 VGND.n755 VGND.n754 9.3005
R1661 VGND.n195 VGND.n194 9.3005
R1662 VGND.n768 VGND.n767 9.3005
R1663 VGND.n769 VGND.n193 9.3005
R1664 VGND.n771 VGND.n770 9.3005
R1665 VGND.n181 VGND.n180 9.3005
R1666 VGND.n784 VGND.n783 9.3005
R1667 VGND.n789 VGND.n179 9.3005
R1668 VGND.n791 VGND.n790 9.3005
R1669 VGND.n167 VGND.n166 9.3005
R1670 VGND.n804 VGND.n803 9.3005
R1671 VGND.n805 VGND.n165 9.3005
R1672 VGND.n807 VGND.n806 9.3005
R1673 VGND.n153 VGND.n152 9.3005
R1674 VGND.n820 VGND.n819 9.3005
R1675 VGND.n825 VGND.n151 9.3005
R1676 VGND.n827 VGND.n826 9.3005
R1677 VGND.n139 VGND.n138 9.3005
R1678 VGND.n840 VGND.n839 9.3005
R1679 VGND.n853 VGND.n137 9.3005
R1680 VGND.n855 VGND.n854 9.3005
R1681 VGND.n125 VGND.n124 9.3005
R1682 VGND.n868 VGND.n867 9.3005
R1683 VGND.n871 VGND.n122 9.3005
R1684 VGND.n877 VGND.n876 9.3005
R1685 VGND.n875 VGND.n123 9.3005
R1686 VGND.n874 VGND.n873 9.3005
R1687 VGND.n872 VGND.n4 9.3005
R1688 VGND.n945 VGND.n1 9.3005
R1689 VGND.n947 VGND.n946 9.3005
R1690 VGND.n608 VGND.n328 9.3005
R1691 VGND.n607 VGND.n606 9.3005
R1692 VGND.n330 VGND.n329 9.3005
R1693 VGND.n601 VGND.n600 9.3005
R1694 VGND.n599 VGND.n332 9.3005
R1695 VGND.n598 VGND.n597 9.3005
R1696 VGND.n334 VGND.n333 9.3005
R1697 VGND.n591 VGND.n590 9.3005
R1698 VGND.n589 VGND.n336 9.3005
R1699 VGND.n588 VGND.n587 9.3005
R1700 VGND.n338 VGND.n337 9.3005
R1701 VGND.n578 VGND.n577 9.3005
R1702 VGND.n576 VGND.n437 9.3005
R1703 VGND.n575 VGND.n574 9.3005
R1704 VGND.n573 VGND.n440 9.3005
R1705 VGND.n572 VGND.n571 9.3005
R1706 VGND.n570 VGND.n441 9.3005
R1707 VGND.n569 VGND.n568 9.3005
R1708 VGND.n567 VGND.n444 9.3005
R1709 VGND.n566 VGND.n565 9.3005
R1710 VGND.n564 VGND.n445 9.3005
R1711 VGND.n563 VGND.n562 9.3005
R1712 VGND.n561 VGND.n448 9.3005
R1713 VGND.n560 VGND.n559 9.3005
R1714 VGND.n558 VGND.n449 9.3005
R1715 VGND.n557 VGND.n556 9.3005
R1716 VGND.n555 VGND.n452 9.3005
R1717 VGND.n554 VGND.n553 9.3005
R1718 VGND.n552 VGND.n453 9.3005
R1719 VGND.n551 VGND.n550 9.3005
R1720 VGND.n549 VGND.n456 9.3005
R1721 VGND.n548 VGND.n547 9.3005
R1722 VGND.n546 VGND.n457 9.3005
R1723 VGND.n545 VGND.n544 9.3005
R1724 VGND.n543 VGND.n460 9.3005
R1725 VGND.n542 VGND.n541 9.3005
R1726 VGND.n540 VGND.n461 9.3005
R1727 VGND.n539 VGND.n538 9.3005
R1728 VGND.n537 VGND.n464 9.3005
R1729 VGND.n536 VGND.n535 9.3005
R1730 VGND.n534 VGND.n465 9.3005
R1731 VGND.n533 VGND.n532 9.3005
R1732 VGND.n531 VGND.n468 9.3005
R1733 VGND.n530 VGND.n529 9.3005
R1734 VGND.n528 VGND.n469 9.3005
R1735 VGND.n527 VGND.n526 9.3005
R1736 VGND.n525 VGND.n472 9.3005
R1737 VGND.n524 VGND.n523 9.3005
R1738 VGND.n522 VGND.n473 9.3005
R1739 VGND.n521 VGND.n520 9.3005
R1740 VGND.n519 VGND.n476 9.3005
R1741 VGND.n518 VGND.n517 9.3005
R1742 VGND.n516 VGND.n477 9.3005
R1743 VGND.n515 VGND.n514 9.3005
R1744 VGND.n513 VGND.n480 9.3005
R1745 VGND.n512 VGND.n511 9.3005
R1746 VGND.n510 VGND.n481 9.3005
R1747 VGND.n509 VGND.n508 9.3005
R1748 VGND.n507 VGND.n484 9.3005
R1749 VGND.n506 VGND.n505 9.3005
R1750 VGND.n504 VGND.n485 9.3005
R1751 VGND.n503 VGND.n502 9.3005
R1752 VGND.n501 VGND.n488 9.3005
R1753 VGND.n500 VGND.n499 9.3005
R1754 VGND.n498 VGND.n489 9.3005
R1755 VGND.n497 VGND.n496 9.3005
R1756 VGND.n495 VGND.n492 9.3005
R1757 VGND.n494 VGND.n493 9.3005
R1758 VGND.n108 VGND.n107 9.3005
R1759 VGND.n890 VGND.n889 9.3005
R1760 VGND.n891 VGND.n106 9.3005
R1761 VGND.n893 VGND.n892 9.3005
R1762 VGND.n105 VGND.n104 9.3005
R1763 VGND.n103 VGND.n75 9.3005
R1764 VGND.n102 VGND.n101 9.3005
R1765 VGND.n100 VGND.n76 9.3005
R1766 VGND.n99 VGND.n98 9.3005
R1767 VGND.n97 VGND.n82 9.3005
R1768 VGND.n96 VGND.n95 9.3005
R1769 VGND.n94 VGND.n83 9.3005
R1770 VGND.n93 VGND.n92 9.3005
R1771 VGND.n2 VGND.n0 9.3005
R1772 VGND.n939 VGND.n12 9.3005
R1773 VGND.n938 VGND.n937 9.3005
R1774 VGND.n936 VGND.n14 9.3005
R1775 VGND.n935 VGND.n934 9.3005
R1776 VGND.n933 VGND.n20 9.3005
R1777 VGND.n932 VGND.n931 9.3005
R1778 VGND.n930 VGND.n21 9.3005
R1779 VGND.n929 VGND.n928 9.3005
R1780 VGND.n927 VGND.n28 9.3005
R1781 VGND.n926 VGND.n925 9.3005
R1782 VGND.n924 VGND.n29 9.3005
R1783 VGND.n923 VGND.n922 9.3005
R1784 VGND.n921 VGND.n36 9.3005
R1785 VGND.n920 VGND.n919 9.3005
R1786 VGND.n918 VGND.n37 9.3005
R1787 VGND.n917 VGND.n916 9.3005
R1788 VGND.n915 VGND.n44 9.3005
R1789 VGND.n914 VGND.n913 9.3005
R1790 VGND.n912 VGND.n45 9.3005
R1791 VGND.n911 VGND.n910 9.3005
R1792 VGND.n909 VGND.n52 9.3005
R1793 VGND.n908 VGND.n907 9.3005
R1794 VGND.n906 VGND.n53 9.3005
R1795 VGND.n905 VGND.n904 9.3005
R1796 VGND.n903 VGND.n60 9.3005
R1797 VGND.n902 VGND.n901 9.3005
R1798 VGND.n900 VGND.n61 9.3005
R1799 VGND.n899 VGND.n898 9.3005
R1800 VGND.n897 VGND.n68 9.3005
R1801 VGND.n896 VGND.n895 9.3005
R1802 VGND.n941 VGND.n940 9.3005
R1803 VGND.n13 VGND.n11 9.3005
R1804 VGND.n885 VGND.n884 9.3005
R1805 VGND.n883 VGND.n114 9.3005
R1806 VGND.n882 VGND.n881 9.3005
R1807 VGND.n116 VGND.n115 9.3005
R1808 VGND.n863 VGND.n862 9.3005
R1809 VGND.n861 VGND.n130 9.3005
R1810 VGND.n860 VGND.n859 9.3005
R1811 VGND.n132 VGND.n131 9.3005
R1812 VGND.n835 VGND.n834 9.3005
R1813 VGND.n833 VGND.n144 9.3005
R1814 VGND.n832 VGND.n831 9.3005
R1815 VGND.n146 VGND.n145 9.3005
R1816 VGND.n815 VGND.n814 9.3005
R1817 VGND.n813 VGND.n158 9.3005
R1818 VGND.n812 VGND.n811 9.3005
R1819 VGND.n160 VGND.n159 9.3005
R1820 VGND.n799 VGND.n798 9.3005
R1821 VGND.n797 VGND.n172 9.3005
R1822 VGND.n796 VGND.n795 9.3005
R1823 VGND.n174 VGND.n173 9.3005
R1824 VGND.n779 VGND.n778 9.3005
R1825 VGND.n777 VGND.n186 9.3005
R1826 VGND.n776 VGND.n775 9.3005
R1827 VGND.n188 VGND.n187 9.3005
R1828 VGND.n763 VGND.n762 9.3005
R1829 VGND.n761 VGND.n200 9.3005
R1830 VGND.n760 VGND.n759 9.3005
R1831 VGND.n202 VGND.n201 9.3005
R1832 VGND.n747 VGND.n746 9.3005
R1833 VGND.n745 VGND.n217 9.3005
R1834 VGND.n744 VGND.n743 9.3005
R1835 VGND.n219 VGND.n218 9.3005
R1836 VGND.n730 VGND.n729 9.3005
R1837 VGND.n728 VGND.n231 9.3005
R1838 VGND.n727 VGND.n726 9.3005
R1839 VGND.n233 VGND.n232 9.3005
R1840 VGND.n714 VGND.n713 9.3005
R1841 VGND.n712 VGND.n248 9.3005
R1842 VGND.n711 VGND.n710 9.3005
R1843 VGND.n250 VGND.n249 9.3005
R1844 VGND.n697 VGND.n696 9.3005
R1845 VGND.n695 VGND.n262 9.3005
R1846 VGND.n694 VGND.n693 9.3005
R1847 VGND.n264 VGND.n263 9.3005
R1848 VGND.n681 VGND.n680 9.3005
R1849 VGND.n679 VGND.n279 9.3005
R1850 VGND.n678 VGND.n677 9.3005
R1851 VGND.n281 VGND.n280 9.3005
R1852 VGND.n664 VGND.n663 9.3005
R1853 VGND.n662 VGND.n293 9.3005
R1854 VGND.n661 VGND.n660 9.3005
R1855 VGND.n295 VGND.n294 9.3005
R1856 VGND.n636 VGND.n635 9.3005
R1857 VGND.n634 VGND.n307 9.3005
R1858 VGND.n633 VGND.n632 9.3005
R1859 VGND.n309 VGND.n308 9.3005
R1860 VGND.n618 VGND.n617 9.3005
R1861 VGND.n616 VGND.n321 9.3005
R1862 VGND.n615 VGND.n614 9.3005
R1863 VGND.n581 VGND.n580 9.3005
R1864 VGND.n436 VGND.n340 9.3005
R1865 VGND.n435 VGND.n434 9.3005
R1866 VGND.n343 VGND.n342 9.3005
R1867 VGND.n429 VGND.n428 9.3005
R1868 VGND.n427 VGND.n346 9.3005
R1869 VGND.n426 VGND.n425 9.3005
R1870 VGND.n348 VGND.n347 9.3005
R1871 VGND.n419 VGND.n418 9.3005
R1872 VGND.n417 VGND.n350 9.3005
R1873 VGND.n416 VGND.n415 9.3005
R1874 VGND.n352 VGND.n351 9.3005
R1875 VGND.n409 VGND.n408 9.3005
R1876 VGND.n407 VGND.n354 9.3005
R1877 VGND.n406 VGND.n405 9.3005
R1878 VGND.n356 VGND.n355 9.3005
R1879 VGND.n399 VGND.n398 9.3005
R1880 VGND.n397 VGND.n358 9.3005
R1881 VGND.n396 VGND.n395 9.3005
R1882 VGND.n360 VGND.n359 9.3005
R1883 VGND.n390 VGND.n389 9.3005
R1884 VGND.n388 VGND.n362 9.3005
R1885 VGND.n387 VGND.n386 9.3005
R1886 VGND.n364 VGND.n363 9.3005
R1887 VGND.n380 VGND.n379 9.3005
R1888 VGND.n378 VGND.n366 9.3005
R1889 VGND.n377 VGND.n376 9.3005
R1890 VGND.n368 VGND.n367 9.3005
R1891 VGND.n370 VGND.n369 9.3005
R1892 VGND.n323 VGND.n322 9.3005
R1893 VGND.n773 VGND.t6 7.74244
R1894 VGND.n757 VGND.t7 7.74244
R1895 VGND.n291 VGND.t2 7.74244
R1896 VGND.t3 VGND.n297 7.74244
R1897 VGND.n653 VGND.n652 4.50239
R1898 VGND.n851 VGND.n850 4.50239
R1899 VGND.n647 VGND.n646 4.5005
R1900 VGND.n845 VGND.n844 4.5005
R1901 VGND.n646 VGND.n645 2.90514
R1902 VGND.n844 VGND.n843 2.90514
R1903 VGND.n870 VGND.n869 2.72619
R1904 VGND.n824 VGND.n823 2.72619
R1905 VGND.n788 VGND.n787 2.72619
R1906 VGND.n210 VGND.n209 2.72619
R1907 VGND.n241 VGND.n240 2.72619
R1908 VGND.n272 VGND.n271 2.72619
R1909 VGND.n626 VGND.n625 2.71945
R1910 VGND.n852 VGND.n851 2.66587
R1911 VGND.n654 VGND.n653 2.6605
R1912 VGND.n940 VGND.n939 0.459739
R1913 VGND.n615 VGND.n322 0.459739
R1914 VGND.n645 VGND.n643 0.292945
R1915 VGND.n843 VGND.n841 0.292945
R1916 VGND.n896 VGND.n69 0.288543
R1917 VGND.n580 VGND.n579 0.288543
R1918 VGND.n579 VGND.n337 0.272239
R1919 VGND.n104 VGND.n69 0.272239
R1920 VGND.n649 VGND.n648 0.254943
R1921 VGND.n847 VGND.n846 0.254943
R1922 VGND.n607 VGND.n329 0.196152
R1923 VGND.n600 VGND.n329 0.196152
R1924 VGND.n600 VGND.n599 0.196152
R1925 VGND.n599 VGND.n598 0.196152
R1926 VGND.n598 VGND.n333 0.196152
R1927 VGND.n590 VGND.n333 0.196152
R1928 VGND.n590 VGND.n589 0.196152
R1929 VGND.n589 VGND.n588 0.196152
R1930 VGND.n588 VGND.n337 0.196152
R1931 VGND.n892 VGND.n891 0.196152
R1932 VGND.n891 VGND.n890 0.196152
R1933 VGND.n890 VGND.n107 0.196152
R1934 VGND.n494 VGND.n107 0.196152
R1935 VGND.n495 VGND.n494 0.196152
R1936 VGND.n496 VGND.n495 0.196152
R1937 VGND.n496 VGND.n489 0.196152
R1938 VGND.n500 VGND.n489 0.196152
R1939 VGND.n501 VGND.n500 0.196152
R1940 VGND.n502 VGND.n501 0.196152
R1941 VGND.n502 VGND.n485 0.196152
R1942 VGND.n506 VGND.n485 0.196152
R1943 VGND.n507 VGND.n506 0.196152
R1944 VGND.n508 VGND.n507 0.196152
R1945 VGND.n508 VGND.n481 0.196152
R1946 VGND.n512 VGND.n481 0.196152
R1947 VGND.n513 VGND.n512 0.196152
R1948 VGND.n514 VGND.n513 0.196152
R1949 VGND.n514 VGND.n477 0.196152
R1950 VGND.n518 VGND.n477 0.196152
R1951 VGND.n519 VGND.n518 0.196152
R1952 VGND.n520 VGND.n519 0.196152
R1953 VGND.n520 VGND.n473 0.196152
R1954 VGND.n524 VGND.n473 0.196152
R1955 VGND.n525 VGND.n524 0.196152
R1956 VGND.n526 VGND.n525 0.196152
R1957 VGND.n526 VGND.n469 0.196152
R1958 VGND.n530 VGND.n469 0.196152
R1959 VGND.n531 VGND.n530 0.196152
R1960 VGND.n532 VGND.n531 0.196152
R1961 VGND.n532 VGND.n465 0.196152
R1962 VGND.n536 VGND.n465 0.196152
R1963 VGND.n537 VGND.n536 0.196152
R1964 VGND.n538 VGND.n537 0.196152
R1965 VGND.n538 VGND.n461 0.196152
R1966 VGND.n542 VGND.n461 0.196152
R1967 VGND.n543 VGND.n542 0.196152
R1968 VGND.n544 VGND.n543 0.196152
R1969 VGND.n544 VGND.n457 0.196152
R1970 VGND.n548 VGND.n457 0.196152
R1971 VGND.n549 VGND.n548 0.196152
R1972 VGND.n550 VGND.n549 0.196152
R1973 VGND.n550 VGND.n453 0.196152
R1974 VGND.n554 VGND.n453 0.196152
R1975 VGND.n555 VGND.n554 0.196152
R1976 VGND.n556 VGND.n555 0.196152
R1977 VGND.n556 VGND.n449 0.196152
R1978 VGND.n560 VGND.n449 0.196152
R1979 VGND.n561 VGND.n560 0.196152
R1980 VGND.n562 VGND.n561 0.196152
R1981 VGND.n562 VGND.n445 0.196152
R1982 VGND.n566 VGND.n445 0.196152
R1983 VGND.n567 VGND.n566 0.196152
R1984 VGND.n568 VGND.n567 0.196152
R1985 VGND.n568 VGND.n441 0.196152
R1986 VGND.n572 VGND.n441 0.196152
R1987 VGND.n573 VGND.n572 0.196152
R1988 VGND.n574 VGND.n573 0.196152
R1989 VGND.n574 VGND.n437 0.196152
R1990 VGND.n578 VGND.n437 0.196152
R1991 VGND.n92 VGND.n0 0.196152
R1992 VGND.n92 VGND.n83 0.196152
R1993 VGND.n96 VGND.n83 0.196152
R1994 VGND.n97 VGND.n96 0.196152
R1995 VGND.n98 VGND.n97 0.196152
R1996 VGND.n98 VGND.n76 0.196152
R1997 VGND.n102 VGND.n76 0.196152
R1998 VGND.n103 VGND.n102 0.196152
R1999 VGND.n104 VGND.n103 0.196152
R2000 VGND.n897 VGND.n896 0.196152
R2001 VGND.n898 VGND.n897 0.196152
R2002 VGND.n898 VGND.n61 0.196152
R2003 VGND.n902 VGND.n61 0.196152
R2004 VGND.n903 VGND.n902 0.196152
R2005 VGND.n904 VGND.n903 0.196152
R2006 VGND.n904 VGND.n53 0.196152
R2007 VGND.n908 VGND.n53 0.196152
R2008 VGND.n909 VGND.n908 0.196152
R2009 VGND.n910 VGND.n909 0.196152
R2010 VGND.n910 VGND.n45 0.196152
R2011 VGND.n914 VGND.n45 0.196152
R2012 VGND.n915 VGND.n914 0.196152
R2013 VGND.n916 VGND.n915 0.196152
R2014 VGND.n916 VGND.n37 0.196152
R2015 VGND.n920 VGND.n37 0.196152
R2016 VGND.n921 VGND.n920 0.196152
R2017 VGND.n922 VGND.n921 0.196152
R2018 VGND.n922 VGND.n29 0.196152
R2019 VGND.n926 VGND.n29 0.196152
R2020 VGND.n927 VGND.n926 0.196152
R2021 VGND.n928 VGND.n927 0.196152
R2022 VGND.n928 VGND.n21 0.196152
R2023 VGND.n932 VGND.n21 0.196152
R2024 VGND.n933 VGND.n932 0.196152
R2025 VGND.n934 VGND.n933 0.196152
R2026 VGND.n934 VGND.n14 0.196152
R2027 VGND.n938 VGND.n14 0.196152
R2028 VGND.n939 VGND.n938 0.196152
R2029 VGND.n940 VGND.n13 0.196152
R2030 VGND.n884 VGND.n13 0.196152
R2031 VGND.n884 VGND.n883 0.196152
R2032 VGND.n883 VGND.n882 0.196152
R2033 VGND.n882 VGND.n115 0.196152
R2034 VGND.n862 VGND.n115 0.196152
R2035 VGND.n862 VGND.n861 0.196152
R2036 VGND.n861 VGND.n860 0.196152
R2037 VGND.n860 VGND.n131 0.196152
R2038 VGND.n834 VGND.n131 0.196152
R2039 VGND.n834 VGND.n833 0.196152
R2040 VGND.n833 VGND.n832 0.196152
R2041 VGND.n832 VGND.n145 0.196152
R2042 VGND.n814 VGND.n145 0.196152
R2043 VGND.n814 VGND.n813 0.196152
R2044 VGND.n813 VGND.n812 0.196152
R2045 VGND.n812 VGND.n159 0.196152
R2046 VGND.n798 VGND.n159 0.196152
R2047 VGND.n798 VGND.n797 0.196152
R2048 VGND.n797 VGND.n796 0.196152
R2049 VGND.n796 VGND.n173 0.196152
R2050 VGND.n778 VGND.n173 0.196152
R2051 VGND.n778 VGND.n777 0.196152
R2052 VGND.n777 VGND.n776 0.196152
R2053 VGND.n776 VGND.n187 0.196152
R2054 VGND.n762 VGND.n187 0.196152
R2055 VGND.n762 VGND.n761 0.196152
R2056 VGND.n761 VGND.n760 0.196152
R2057 VGND.n760 VGND.n201 0.196152
R2058 VGND.n746 VGND.n201 0.196152
R2059 VGND.n746 VGND.n745 0.196152
R2060 VGND.n745 VGND.n744 0.196152
R2061 VGND.n744 VGND.n218 0.196152
R2062 VGND.n729 VGND.n218 0.196152
R2063 VGND.n729 VGND.n728 0.196152
R2064 VGND.n728 VGND.n727 0.196152
R2065 VGND.n727 VGND.n232 0.196152
R2066 VGND.n713 VGND.n232 0.196152
R2067 VGND.n713 VGND.n712 0.196152
R2068 VGND.n712 VGND.n711 0.196152
R2069 VGND.n711 VGND.n249 0.196152
R2070 VGND.n696 VGND.n249 0.196152
R2071 VGND.n696 VGND.n695 0.196152
R2072 VGND.n695 VGND.n694 0.196152
R2073 VGND.n694 VGND.n263 0.196152
R2074 VGND.n680 VGND.n263 0.196152
R2075 VGND.n680 VGND.n679 0.196152
R2076 VGND.n679 VGND.n678 0.196152
R2077 VGND.n678 VGND.n280 0.196152
R2078 VGND.n663 VGND.n280 0.196152
R2079 VGND.n663 VGND.n662 0.196152
R2080 VGND.n662 VGND.n661 0.196152
R2081 VGND.n661 VGND.n294 0.196152
R2082 VGND.n635 VGND.n294 0.196152
R2083 VGND.n635 VGND.n634 0.196152
R2084 VGND.n634 VGND.n633 0.196152
R2085 VGND.n633 VGND.n308 0.196152
R2086 VGND.n617 VGND.n308 0.196152
R2087 VGND.n617 VGND.n616 0.196152
R2088 VGND.n616 VGND.n615 0.196152
R2089 VGND.n580 VGND.n436 0.196152
R2090 VGND.n436 VGND.n435 0.196152
R2091 VGND.n435 VGND.n342 0.196152
R2092 VGND.n428 VGND.n342 0.196152
R2093 VGND.n428 VGND.n427 0.196152
R2094 VGND.n427 VGND.n426 0.196152
R2095 VGND.n426 VGND.n347 0.196152
R2096 VGND.n418 VGND.n347 0.196152
R2097 VGND.n418 VGND.n417 0.196152
R2098 VGND.n417 VGND.n416 0.196152
R2099 VGND.n416 VGND.n351 0.196152
R2100 VGND.n408 VGND.n351 0.196152
R2101 VGND.n408 VGND.n407 0.196152
R2102 VGND.n407 VGND.n406 0.196152
R2103 VGND.n406 VGND.n355 0.196152
R2104 VGND.n398 VGND.n355 0.196152
R2105 VGND.n398 VGND.n397 0.196152
R2106 VGND.n397 VGND.n396 0.196152
R2107 VGND.n396 VGND.n359 0.196152
R2108 VGND.n389 VGND.n359 0.196152
R2109 VGND.n389 VGND.n388 0.196152
R2110 VGND.n388 VGND.n387 0.196152
R2111 VGND.n387 VGND.n363 0.196152
R2112 VGND.n379 VGND.n363 0.196152
R2113 VGND.n379 VGND.n378 0.196152
R2114 VGND.n378 VGND.n377 0.196152
R2115 VGND.n377 VGND.n367 0.196152
R2116 VGND.n369 VGND.n367 0.196152
R2117 VGND.n369 VGND.n322 0.196152
R2118 VGND.n892 VGND.n69 0.171696
R2119 VGND.n579 VGND.n578 0.171696
R2120 VGND.n653 VGND.n646 0.121712
R2121 VGND.n851 VGND.n844 0.121712
R2122 VGND.n652 VGND.n647 0.119818
R2123 VGND.n850 VGND.n845 0.119818
R2124 VGND.n608 VGND.n607 0.117348
R2125 VGND.n947 VGND.n0 0.117348
R2126 VGND.n872 VGND.n1 0.0455
R2127 VGND.n874 VGND.n872 0.0455
R2128 VGND.n875 VGND.n874 0.0455
R2129 VGND.n876 VGND.n875 0.0455
R2130 VGND.n876 VGND.n871 0.0455
R2131 VGND.n868 VGND.n124 0.0455
R2132 VGND.n854 VGND.n124 0.0455
R2133 VGND.n854 VGND.n853 0.0455
R2134 VGND.n840 VGND.n138 0.0455
R2135 VGND.n826 VGND.n138 0.0455
R2136 VGND.n826 VGND.n825 0.0455
R2137 VGND.n820 VGND.n152 0.0455
R2138 VGND.n806 VGND.n152 0.0455
R2139 VGND.n806 VGND.n805 0.0455
R2140 VGND.n805 VGND.n804 0.0455
R2141 VGND.n804 VGND.n166 0.0455
R2142 VGND.n790 VGND.n166 0.0455
R2143 VGND.n790 VGND.n789 0.0455
R2144 VGND.n784 VGND.n180 0.0455
R2145 VGND.n770 VGND.n180 0.0455
R2146 VGND.n770 VGND.n769 0.0455
R2147 VGND.n769 VGND.n768 0.0455
R2148 VGND.n768 VGND.n194 0.0455
R2149 VGND.n754 VGND.n194 0.0455
R2150 VGND.n754 VGND.n753 0.0455
R2151 VGND.n753 VGND.n752 0.0455
R2152 VGND.n738 VGND.n737 0.0455
R2153 VGND.n738 VGND.n736 0.0455
R2154 VGND.n736 VGND.n735 0.0455
R2155 VGND.n735 VGND.n224 0.0455
R2156 VGND.n721 VGND.n224 0.0455
R2157 VGND.n721 VGND.n720 0.0455
R2158 VGND.n720 VGND.n719 0.0455
R2159 VGND.n705 VGND.n704 0.0455
R2160 VGND.n705 VGND.n703 0.0455
R2161 VGND.n703 VGND.n702 0.0455
R2162 VGND.n702 VGND.n255 0.0455
R2163 VGND.n688 VGND.n255 0.0455
R2164 VGND.n688 VGND.n687 0.0455
R2165 VGND.n687 VGND.n686 0.0455
R2166 VGND.n672 VGND.n671 0.0455
R2167 VGND.n672 VGND.n670 0.0455
R2168 VGND.n670 VGND.n669 0.0455
R2169 VGND.n669 VGND.n286 0.0455
R2170 VGND.n655 VGND.n642 0.0455
R2171 VGND.n642 VGND.n641 0.0455
R2172 VGND.n641 VGND.n301 0.0455
R2173 VGND.n627 VGND.n624 0.0455
R2174 VGND.n624 VGND.n623 0.0455
R2175 VGND.n623 VGND.n315 0.0455
R2176 VGND.n609 VGND.n315 0.0455
R2177 VGND.n655 VGND.n654 0.044875
R2178 VGND.n947 VGND.n1 0.039875
R2179 VGND.n609 VGND.n608 0.039875
R2180 VGND.n870 VGND.n868 0.038
R2181 VGND.n686 VGND.n272 0.038
R2182 VGND.n789 VGND.n788 0.037375
R2183 VGND.n737 VGND.n210 0.03675
R2184 VGND.n627 VGND.n626 0.03675
R2185 VGND VGND.n947 0.0305
R2186 VGND.n852 VGND.n840 0.029875
R2187 VGND.n704 VGND.n241 0.024875
R2188 VGND.n825 VGND.n824 0.02425
R2189 VGND.n824 VGND.n820 0.02175
R2190 VGND.n719 VGND.n241 0.021125
R2191 VGND.n649 VGND.n647 0.0175455
R2192 VGND.n847 VGND.n845 0.0175455
R2193 VGND.n853 VGND.n852 0.016125
R2194 VGND.n752 VGND.n210 0.00925
R2195 VGND.n626 VGND.n301 0.00925
R2196 VGND.n788 VGND.n784 0.008625
R2197 VGND.n871 VGND.n870 0.008
R2198 VGND.n671 VGND.n272 0.008
R2199 VGND.n654 VGND.n286 0.001125
R2200 a_433_1469.n103 a_433_1469.n102 184.74
R2201 a_433_1469.n108 a_433_1469.n107 184.74
R2202 a_433_1469.n114 a_433_1469.n113 184.74
R2203 a_433_1469.n119 a_433_1469.n118 184.74
R2204 a_433_1469.n125 a_433_1469.n124 184.74
R2205 a_433_1469.n165 a_433_1469.n129 184.74
R2206 a_433_1469.n159 a_433_1469.n132 184.74
R2207 a_433_1469.n154 a_433_1469.n134 184.74
R2208 a_433_1469.n148 a_433_1469.n137 184.74
R2209 a_433_1469.n143 a_433_1469.n139 184.74
R2210 a_433_1469.n296 a_433_1469.n292 184.74
R2211 a_433_1469.n10 a_433_1469.n9 184.74
R2212 a_433_1469.n251 a_433_1469.n14 184.74
R2213 a_433_1469.n245 a_433_1469.n17 184.74
R2214 a_433_1469.n240 a_433_1469.n19 184.74
R2215 a_433_1469.n234 a_433_1469.n22 184.74
R2216 a_433_1469.n229 a_433_1469.n24 184.74
R2217 a_433_1469.n223 a_433_1469.n27 184.74
R2218 a_433_1469.n218 a_433_1469.n29 184.74
R2219 a_433_1469.n212 a_433_1469.n32 184.74
R2220 a_433_1469.n206 a_433_1469.n35 184.74
R2221 a_433_1469.n287 a_433_1469.t63 129.379
R2222 a_433_1469.n42 a_433_1469.t54 129.377
R2223 a_433_1469.n40 a_433_1469.t78 129.376
R2224 a_433_1469.n41 a_433_1469.t66 129.376
R2225 a_433_1469.n43 a_433_1469.t18 129.376
R2226 a_433_1469.n288 a_433_1469.t75 129.376
R2227 a_433_1469.n286 a_433_1469.t51 129.376
R2228 a_433_1469.n299 a_433_1469.t111 116.188
R2229 a_433_1469.n76 a_433_1469.n74 100.114
R2230 a_433_1469.n79 a_433_1469.n77 100.114
R2231 a_433_1469.n263 a_433_1469.n262 99.3783
R2232 a_433_1469.n67 a_433_1469.n66 99.3783
R2233 a_433_1469.n178 a_433_1469.n177 99.3783
R2234 a_433_1469.n186 a_433_1469.n185 99.3783
R2235 a_433_1469.n69 a_433_1469.n68 99.3768
R2236 a_433_1469.n283 a_433_1469.n282 99.3764
R2237 a_433_1469.n261 a_433_1469.n260 99.3764
R2238 a_433_1469.n265 a_433_1469.n264 99.3764
R2239 a_433_1469.n71 a_433_1469.n70 99.3764
R2240 a_433_1469.n65 a_433_1469.n64 99.3764
R2241 a_433_1469.n76 a_433_1469.n75 99.3764
R2242 a_433_1469.n79 a_433_1469.n78 99.3764
R2243 a_433_1469.n83 a_433_1469.n82 99.3764
R2244 a_433_1469.n174 a_433_1469.n173 99.3764
R2245 a_433_1469.n176 a_433_1469.n175 99.3764
R2246 a_433_1469.n180 a_433_1469.n179 99.3764
R2247 a_433_1469.n188 a_433_1469.n187 99.3764
R2248 a_433_1469.n184 a_433_1469.n183 99.3764
R2249 a_433_1469.n62 a_433_1469.n61 99.3764
R2250 a_433_1469.n247 a_433_1469.n15 97.4694
R2251 a_433_1469.n236 a_433_1469.n20 97.4694
R2252 a_433_1469.n225 a_433_1469.n25 97.4694
R2253 a_433_1469.n214 a_433_1469.n30 97.4694
R2254 a_433_1469.n111 a_433_1469.n96 97.4622
R2255 a_433_1469.n122 a_433_1469.n91 97.4622
R2256 a_433_1469.n161 a_433_1469.n130 97.4622
R2257 a_433_1469.n150 a_433_1469.n135 97.4622
R2258 a_433_1469.n85 a_433_1469.n84 97.1514
R2259 a_433_1469.n87 a_433_1469.n86 97.1031
R2260 a_433_1469.n309 a_433_1469.n308 86.1871
R2261 a_433_1469.n270 a_433_1469.n269 86.1871
R2262 a_433_1469.n278 a_433_1469.n277 86.1871
R2263 a_433_1469.n256 a_433_1469.n255 86.1871
R2264 a_433_1469.n169 a_433_1469.n168 86.1871
R2265 a_433_1469.n192 a_433_1469.n191 86.1871
R2266 a_433_1469.n200 a_433_1469.n199 86.1871
R2267 a_433_1469.n49 a_433_1469.n48 86.1871
R2268 a_433_1469.n57 a_433_1469.n56 86.1871
R2269 a_433_1469.n101 a_433_1469.t49 85.142
R2270 a_433_1469.n140 a_433_1469.t16 85.142
R2271 a_433_1469.n54 a_433_1469.t52 84.9605
R2272 a_433_1469.n267 a_433_1469.t70 84.9556
R2273 a_433_1469.n275 a_433_1469.t58 84.9556
R2274 a_433_1469.n46 a_433_1469.t64 84.9556
R2275 a_433_1469.n202 a_433_1469.t76 84.9556
R2276 a_433_1469.n267 a_433_1469.t73 84.9545
R2277 a_433_1469.n275 a_433_1469.t61 84.9545
R2278 a_433_1469.n46 a_433_1469.t67 84.9545
R2279 a_433_1469.n54 a_433_1469.t55 84.9497
R2280 a_433_1469.n104 a_433_1469.n103 77.1778
R2281 a_433_1469.n109 a_433_1469.n108 77.1778
R2282 a_433_1469.n115 a_433_1469.n114 77.1778
R2283 a_433_1469.n120 a_433_1469.n119 77.1778
R2284 a_433_1469.n126 a_433_1469.n125 77.1778
R2285 a_433_1469.n163 a_433_1469.n129 77.1778
R2286 a_433_1469.n157 a_433_1469.n132 77.1778
R2287 a_433_1469.n152 a_433_1469.n134 77.1778
R2288 a_433_1469.n146 a_433_1469.n137 77.1778
R2289 a_433_1469.n141 a_433_1469.n139 77.1778
R2290 a_433_1469.n294 a_433_1469.n292 77.1778
R2291 a_433_1469.n11 a_433_1469.n10 77.1778
R2292 a_433_1469.n249 a_433_1469.n14 77.1778
R2293 a_433_1469.n243 a_433_1469.n17 77.1778
R2294 a_433_1469.n238 a_433_1469.n19 77.1778
R2295 a_433_1469.n232 a_433_1469.n22 77.1778
R2296 a_433_1469.n227 a_433_1469.n24 77.1778
R2297 a_433_1469.n221 a_433_1469.n27 77.1778
R2298 a_433_1469.n216 a_433_1469.n29 77.1778
R2299 a_433_1469.n210 a_433_1469.n32 77.1778
R2300 a_433_1469.n204 a_433_1469.n35 77.1778
R2301 a_433_1469.n309 a_433_1469.t107 30.0005
R2302 a_433_1469.t110 a_433_1469.n309 30.0005
R2303 a_433_1469.n269 a_433_1469.t71 30.0005
R2304 a_433_1469.n269 a_433_1469.t74 30.0005
R2305 a_433_1469.n277 a_433_1469.t59 30.0005
R2306 a_433_1469.n277 a_433_1469.t62 30.0005
R2307 a_433_1469.n282 a_433_1469.t47 30.0005
R2308 a_433_1469.n282 a_433_1469.t50 30.0005
R2309 a_433_1469.n255 a_433_1469.t104 30.0005
R2310 a_433_1469.n255 a_433_1469.t108 30.0005
R2311 a_433_1469.n260 a_433_1469.t15 30.0005
R2312 a_433_1469.n260 a_433_1469.t72 30.0005
R2313 a_433_1469.n262 a_433_1469.t115 30.0005
R2314 a_433_1469.n262 a_433_1469.t60 30.0005
R2315 a_433_1469.n264 a_433_1469.t44 30.0005
R2316 a_433_1469.n264 a_433_1469.t48 30.0005
R2317 a_433_1469.n70 a_433_1469.t98 30.0005
R2318 a_433_1469.n70 a_433_1469.t101 30.0005
R2319 a_433_1469.n68 a_433_1469.t13 30.0005
R2320 a_433_1469.n68 a_433_1469.t14 30.0005
R2321 a_433_1469.n66 a_433_1469.t113 30.0005
R2322 a_433_1469.n66 a_433_1469.t114 30.0005
R2323 a_433_1469.n64 a_433_1469.t38 30.0005
R2324 a_433_1469.n64 a_433_1469.t41 30.0005
R2325 a_433_1469.n84 a_433_1469.t119 30.0005
R2326 a_433_1469.n84 a_433_1469.t12 30.0005
R2327 a_433_1469.n74 a_433_1469.t6 30.0005
R2328 a_433_1469.n74 a_433_1469.t7 30.0005
R2329 a_433_1469.n75 a_433_1469.t2 30.0005
R2330 a_433_1469.n75 a_433_1469.t3 30.0005
R2331 a_433_1469.n77 a_433_1469.t4 30.0005
R2332 a_433_1469.n77 a_433_1469.t5 30.0005
R2333 a_433_1469.n78 a_433_1469.t0 30.0005
R2334 a_433_1469.n78 a_433_1469.t1 30.0005
R2335 a_433_1469.n82 a_433_1469.t92 30.0005
R2336 a_433_1469.n82 a_433_1469.t95 30.0005
R2337 a_433_1469.n86 a_433_1469.t11 30.0005
R2338 a_433_1469.n86 a_433_1469.t112 30.0005
R2339 a_433_1469.n96 a_433_1469.t42 30.0005
R2340 a_433_1469.n96 a_433_1469.t45 30.0005
R2341 a_433_1469.n91 a_433_1469.t35 30.0005
R2342 a_433_1469.n91 a_433_1469.t39 30.0005
R2343 a_433_1469.n130 a_433_1469.t29 30.0005
R2344 a_433_1469.n130 a_433_1469.t32 30.0005
R2345 a_433_1469.n135 a_433_1469.t23 30.0005
R2346 a_433_1469.n135 a_433_1469.t26 30.0005
R2347 a_433_1469.n168 a_433_1469.t33 30.0005
R2348 a_433_1469.n168 a_433_1469.t36 30.0005
R2349 a_433_1469.n173 a_433_1469.t86 30.0005
R2350 a_433_1469.n173 a_433_1469.t89 30.0005
R2351 a_433_1469.n175 a_433_1469.t117 30.0005
R2352 a_433_1469.n175 a_433_1469.t118 30.0005
R2353 a_433_1469.n177 a_433_1469.t9 30.0005
R2354 a_433_1469.n177 a_433_1469.t10 30.0005
R2355 a_433_1469.n179 a_433_1469.t27 30.0005
R2356 a_433_1469.n179 a_433_1469.t30 30.0005
R2357 a_433_1469.n191 a_433_1469.t80 30.0005
R2358 a_433_1469.n191 a_433_1469.t83 30.0005
R2359 a_433_1469.n187 a_433_1469.t68 30.0005
R2360 a_433_1469.n187 a_433_1469.t116 30.0005
R2361 a_433_1469.n185 a_433_1469.t56 30.0005
R2362 a_433_1469.n185 a_433_1469.t8 30.0005
R2363 a_433_1469.n183 a_433_1469.t20 30.0005
R2364 a_433_1469.n183 a_433_1469.t24 30.0005
R2365 a_433_1469.n199 a_433_1469.t77 30.0005
R2366 a_433_1469.n199 a_433_1469.t81 30.0005
R2367 a_433_1469.n48 a_433_1469.t65 30.0005
R2368 a_433_1469.n48 a_433_1469.t69 30.0005
R2369 a_433_1469.n56 a_433_1469.t53 30.0005
R2370 a_433_1469.n56 a_433_1469.t57 30.0005
R2371 a_433_1469.n61 a_433_1469.t17 30.0005
R2372 a_433_1469.n61 a_433_1469.t21 30.0005
R2373 a_433_1469.n15 a_433_1469.t102 30.0005
R2374 a_433_1469.n15 a_433_1469.t105 30.0005
R2375 a_433_1469.n20 a_433_1469.t96 30.0005
R2376 a_433_1469.n20 a_433_1469.t99 30.0005
R2377 a_433_1469.n25 a_433_1469.t90 30.0005
R2378 a_433_1469.n25 a_433_1469.t93 30.0005
R2379 a_433_1469.n30 a_433_1469.t84 30.0005
R2380 a_433_1469.n30 a_433_1469.t87 30.0005
R2381 a_433_1469.n102 a_433_1469.n100 27.1064
R2382 a_433_1469.n107 a_433_1469.n98 27.1064
R2383 a_433_1469.n113 a_433_1469.n95 27.1064
R2384 a_433_1469.n118 a_433_1469.n93 27.1064
R2385 a_433_1469.n124 a_433_1469.n90 27.1064
R2386 a_433_1469.n165 a_433_1469.n164 27.1064
R2387 a_433_1469.n159 a_433_1469.n158 27.1064
R2388 a_433_1469.n154 a_433_1469.n153 27.1064
R2389 a_433_1469.n148 a_433_1469.n147 27.1064
R2390 a_433_1469.n143 a_433_1469.n142 27.1064
R2391 a_433_1469.n296 a_433_1469.n295 27.1064
R2392 a_433_1469.n9 a_433_1469.n7 27.1064
R2393 a_433_1469.n251 a_433_1469.n250 27.1064
R2394 a_433_1469.n245 a_433_1469.n244 27.1064
R2395 a_433_1469.n240 a_433_1469.n239 27.1064
R2396 a_433_1469.n234 a_433_1469.n233 27.1064
R2397 a_433_1469.n229 a_433_1469.n228 27.1064
R2398 a_433_1469.n223 a_433_1469.n222 27.1064
R2399 a_433_1469.n218 a_433_1469.n217 27.1064
R2400 a_433_1469.n212 a_433_1469.n211 27.1064
R2401 a_433_1469.n206 a_433_1469.n205 27.1064
R2402 a_433_1469.n103 a_433_1469.t46 24.1005
R2403 a_433_1469.n108 a_433_1469.t43 24.1005
R2404 a_433_1469.n114 a_433_1469.t40 24.1005
R2405 a_433_1469.n119 a_433_1469.t37 24.1005
R2406 a_433_1469.n125 a_433_1469.t34 24.1005
R2407 a_433_1469.n129 a_433_1469.t31 24.1005
R2408 a_433_1469.n132 a_433_1469.t28 24.1005
R2409 a_433_1469.n134 a_433_1469.t25 24.1005
R2410 a_433_1469.n137 a_433_1469.t22 24.1005
R2411 a_433_1469.n139 a_433_1469.t19 24.1005
R2412 a_433_1469.n292 a_433_1469.t109 24.1005
R2413 a_433_1469.n10 a_433_1469.t106 24.1005
R2414 a_433_1469.n14 a_433_1469.t103 24.1005
R2415 a_433_1469.n17 a_433_1469.t100 24.1005
R2416 a_433_1469.n19 a_433_1469.t97 24.1005
R2417 a_433_1469.n22 a_433_1469.t94 24.1005
R2418 a_433_1469.n24 a_433_1469.t91 24.1005
R2419 a_433_1469.n27 a_433_1469.t88 24.1005
R2420 a_433_1469.n29 a_433_1469.t85 24.1005
R2421 a_433_1469.n32 a_433_1469.t82 24.1005
R2422 a_433_1469.n35 a_433_1469.t79 24.1005
R2423 a_433_1469.n105 a_433_1469.n104 23.0638
R2424 a_433_1469.n110 a_433_1469.n109 23.0638
R2425 a_433_1469.n116 a_433_1469.n115 23.0638
R2426 a_433_1469.n121 a_433_1469.n120 23.0638
R2427 a_433_1469.n127 a_433_1469.n126 23.0638
R2428 a_433_1469.n163 a_433_1469.n162 23.0638
R2429 a_433_1469.n157 a_433_1469.n156 23.0638
R2430 a_433_1469.n152 a_433_1469.n151 23.0638
R2431 a_433_1469.n146 a_433_1469.n145 23.0638
R2432 a_433_1469.n141 a_433_1469.n140 23.0638
R2433 a_433_1469.n294 a_433_1469.n293 23.0638
R2434 a_433_1469.n12 a_433_1469.n11 23.0638
R2435 a_433_1469.n249 a_433_1469.n248 23.0638
R2436 a_433_1469.n243 a_433_1469.n242 23.0638
R2437 a_433_1469.n238 a_433_1469.n237 23.0638
R2438 a_433_1469.n232 a_433_1469.n231 23.0638
R2439 a_433_1469.n227 a_433_1469.n226 23.0638
R2440 a_433_1469.n221 a_433_1469.n220 23.0638
R2441 a_433_1469.n216 a_433_1469.n215 23.0638
R2442 a_433_1469.n210 a_433_1469.n209 23.0638
R2443 a_433_1469.n204 a_433_1469.n203 23.0638
R2444 a_433_1469.n308 a_433_1469.n0 21.9364
R2445 a_433_1469.n300 a_433_1469.n299 21.9364
R2446 a_433_1469.n271 a_433_1469.n270 21.9364
R2447 a_433_1469.n257 a_433_1469.n256 21.9364
R2448 a_433_1469.n193 a_433_1469.n192 21.9364
R2449 a_433_1469.n200 a_433_1469.n198 21.9364
R2450 a_433_1469.n50 a_433_1469.n49 21.9364
R2451 a_433_1469.n308 a_433_1469.n307 21.9288
R2452 a_433_1469.n299 a_433_1469.n298 21.9288
R2453 a_433_1469.n270 a_433_1469.n268 21.9288
R2454 a_433_1469.n278 a_433_1469.n276 21.9288
R2455 a_433_1469.n279 a_433_1469.n278 21.9288
R2456 a_433_1469.n256 a_433_1469.n254 21.9288
R2457 a_433_1469.n170 a_433_1469.n169 21.9288
R2458 a_433_1469.n169 a_433_1469.n88 21.9288
R2459 a_433_1469.n192 a_433_1469.n33 21.9288
R2460 a_433_1469.n201 a_433_1469.n200 21.9288
R2461 a_433_1469.n49 a_433_1469.n47 21.9288
R2462 a_433_1469.n57 a_433_1469.n55 21.9288
R2463 a_433_1469.n58 a_433_1469.n57 21.9288
R2464 a_433_1469.n104 a_433_1469.n100 11.3247
R2465 a_433_1469.n109 a_433_1469.n98 11.3247
R2466 a_433_1469.n115 a_433_1469.n95 11.3247
R2467 a_433_1469.n120 a_433_1469.n93 11.3247
R2468 a_433_1469.n126 a_433_1469.n90 11.3247
R2469 a_433_1469.n164 a_433_1469.n163 11.3247
R2470 a_433_1469.n158 a_433_1469.n157 11.3247
R2471 a_433_1469.n153 a_433_1469.n152 11.3247
R2472 a_433_1469.n147 a_433_1469.n146 11.3247
R2473 a_433_1469.n142 a_433_1469.n141 11.3247
R2474 a_433_1469.n295 a_433_1469.n294 11.3247
R2475 a_433_1469.n11 a_433_1469.n7 11.3247
R2476 a_433_1469.n250 a_433_1469.n249 11.3247
R2477 a_433_1469.n244 a_433_1469.n243 11.3247
R2478 a_433_1469.n239 a_433_1469.n238 11.3247
R2479 a_433_1469.n233 a_433_1469.n232 11.3247
R2480 a_433_1469.n228 a_433_1469.n227 11.3247
R2481 a_433_1469.n222 a_433_1469.n221 11.3247
R2482 a_433_1469.n217 a_433_1469.n216 11.3247
R2483 a_433_1469.n211 a_433_1469.n210 11.3247
R2484 a_433_1469.n205 a_433_1469.n204 11.3247
R2485 a_433_1469.n207 a_433_1469.n206 9.3005
R2486 a_433_1469.n205 a_433_1469.n34 9.3005
R2487 a_433_1469.n213 a_433_1469.n212 9.3005
R2488 a_433_1469.n211 a_433_1469.n31 9.3005
R2489 a_433_1469.n219 a_433_1469.n218 9.3005
R2490 a_433_1469.n217 a_433_1469.n28 9.3005
R2491 a_433_1469.n224 a_433_1469.n223 9.3005
R2492 a_433_1469.n222 a_433_1469.n26 9.3005
R2493 a_433_1469.n230 a_433_1469.n229 9.3005
R2494 a_433_1469.n228 a_433_1469.n23 9.3005
R2495 a_433_1469.n235 a_433_1469.n234 9.3005
R2496 a_433_1469.n233 a_433_1469.n21 9.3005
R2497 a_433_1469.n241 a_433_1469.n240 9.3005
R2498 a_433_1469.n239 a_433_1469.n18 9.3005
R2499 a_433_1469.n246 a_433_1469.n245 9.3005
R2500 a_433_1469.n244 a_433_1469.n16 9.3005
R2501 a_433_1469.n252 a_433_1469.n251 9.3005
R2502 a_433_1469.n250 a_433_1469.n13 9.3005
R2503 a_433_1469.n9 a_433_1469.n8 9.3005
R2504 a_433_1469.n7 a_433_1469.n6 9.3005
R2505 a_433_1469.n297 a_433_1469.n296 9.3005
R2506 a_433_1469.n295 a_433_1469.n291 9.3005
R2507 a_433_1469.n144 a_433_1469.n143 9.3005
R2508 a_433_1469.n142 a_433_1469.n138 9.3005
R2509 a_433_1469.n149 a_433_1469.n148 9.3005
R2510 a_433_1469.n147 a_433_1469.n136 9.3005
R2511 a_433_1469.n155 a_433_1469.n154 9.3005
R2512 a_433_1469.n153 a_433_1469.n133 9.3005
R2513 a_433_1469.n160 a_433_1469.n159 9.3005
R2514 a_433_1469.n158 a_433_1469.n131 9.3005
R2515 a_433_1469.n166 a_433_1469.n165 9.3005
R2516 a_433_1469.n164 a_433_1469.n128 9.3005
R2517 a_433_1469.n124 a_433_1469.n123 9.3005
R2518 a_433_1469.n90 a_433_1469.n89 9.3005
R2519 a_433_1469.n118 a_433_1469.n117 9.3005
R2520 a_433_1469.n93 a_433_1469.n92 9.3005
R2521 a_433_1469.n113 a_433_1469.n112 9.3005
R2522 a_433_1469.n95 a_433_1469.n94 9.3005
R2523 a_433_1469.n107 a_433_1469.n106 9.3005
R2524 a_433_1469.n98 a_433_1469.n97 9.3005
R2525 a_433_1469.n102 a_433_1469.n101 9.3005
R2526 a_433_1469.n100 a_433_1469.n99 9.3005
R2527 a_433_1469.n44 a_433_1469.n38 9.20923
R2528 a_433_1469.n302 a_433_1469.n285 9.1144
R2529 a_433_1469.n172 a_433_1469.n171 5.25762
R2530 a_433_1469.n279 a_433_1469.n274 4.50429
R2531 a_433_1469.n58 a_433_1469.n53 4.50429
R2532 a_433_1469.n304 a_433_1469.n0 4.5005
R2533 a_433_1469.n306 a_433_1469.n305 4.5005
R2534 a_433_1469.n301 a_433_1469.n300 4.5005
R2535 a_433_1469.n290 a_433_1469.n289 4.5005
R2536 a_433_1469.n281 a_433_1469.n280 4.5005
R2537 a_433_1469.n271 a_433_1469.n2 4.5005
R2538 a_433_1469.n273 a_433_1469.n272 4.5005
R2539 a_433_1469.n257 a_433_1469.n5 4.5005
R2540 a_433_1469.n259 a_433_1469.n258 4.5005
R2541 a_433_1469.n194 a_433_1469.n193 4.5005
R2542 a_433_1469.n190 a_433_1469.n189 4.5005
R2543 a_433_1469.n60 a_433_1469.n59 4.5005
R2544 a_433_1469.n50 a_433_1469.n45 4.5005
R2545 a_433_1469.n52 a_433_1469.n51 4.5005
R2546 a_433_1469.n198 a_433_1469.n197 4.5005
R2547 a_433_1469.n37 a_433_1469.n36 4.5005
R2548 a_433_1469.n286 a_433_1469.n285 3.06955
R2549 a_433_1469.n44 a_433_1469.n43 3.06895
R2550 a_433_1469.n63 a_433_1469.n62 3.06895
R2551 a_433_1469.n184 a_433_1469.n182 3.06895
R2552 a_433_1469.n181 a_433_1469.n180 3.06895
R2553 a_433_1469.n65 a_433_1469.n4 3.06895
R2554 a_433_1469.n266 a_433_1469.n265 3.06895
R2555 a_433_1469.n284 a_433_1469.n283 3.06895
R2556 a_433_1469.n85 a_433_1469.n83 2.95979
R2557 a_433_1469.n72 a_433_1469.n71 2.94196
R2558 a_433_1469.n40 a_433_1469.n38 2.94136
R2559 a_433_1469.n174 a_433_1469.n39 2.94136
R2560 a_433_1469.n195 a_433_1469.n194 2.88225
R2561 a_433_1469.n197 a_433_1469.n196 2.88105
R2562 a_433_1469.n302 a_433_1469.n301 2.88045
R2563 a_433_1469.n304 a_433_1469.n303 2.87985
R2564 a_433_1469.n5 a_433_1469.n3 2.87985
R2565 a_433_1469.n80 a_433_1469.n76 2.83525
R2566 a_433_1469.n80 a_433_1469.n79 2.83135
R2567 a_433_1469.n81 a_433_1469.n73 2.21678
R2568 a_433_1469.n81 a_433_1469.n80 1.99111
R2569 a_433_1469.n195 a_433_1469.n39 1.45793
R2570 a_433_1469.n73 a_433_1469.n39 1.45076
R2571 a_433_1469.n172 a_433_1469.n4 1.44603
R2572 a_433_1469.n181 a_433_1469.n172 1.43882
R2573 a_433_1469.n182 a_433_1469.n181 1.43641
R2574 a_433_1469.n266 a_433_1469.n4 1.43641
R2575 a_433_1469.n73 a_433_1469.n72 1.43407
R2576 a_433_1469.n72 a_433_1469.n3 1.42926
R2577 a_433_1469.n87 a_433_1469.n85 1.04418
R2578 a_433_1469.n88 a_433_1469.n87 0.997542
R2579 a_433_1469.n287 a_433_1469.n286 0.747992
R2580 a_433_1469.n265 a_433_1469.n263 0.747992
R2581 a_433_1469.n67 a_433_1469.n65 0.747992
R2582 a_433_1469.n180 a_433_1469.n178 0.747992
R2583 a_433_1469.n186 a_433_1469.n184 0.747992
R2584 a_433_1469.n43 a_433_1469.n42 0.74611
R2585 a_433_1469.n42 a_433_1469.n41 0.734771
R2586 a_433_1469.n176 a_433_1469.n174 0.734759
R2587 a_433_1469.n41 a_433_1469.n40 0.734759
R2588 a_433_1469.n288 a_433_1469.n287 0.73289
R2589 a_433_1469.n263 a_433_1469.n261 0.73289
R2590 a_433_1469.n178 a_433_1469.n176 0.73289
R2591 a_433_1469.n188 a_433_1469.n186 0.73289
R2592 a_433_1469.n71 a_433_1469.n69 0.732804
R2593 a_433_1469.n69 a_433_1469.n67 0.730934
R2594 a_433_1469.n83 a_433_1469.n81 0.727478
R2595 a_433_1469.n182 a_433_1469.n63 0.724876
R2596 a_433_1469.n196 a_433_1469.n38 0.72007
R2597 a_433_1469.n303 a_433_1469.n3 0.720068
R2598 a_433_1469.n63 a_433_1469.n44 0.720068
R2599 a_433_1469.n284 a_433_1469.n266 0.720068
R2600 a_433_1469.n196 a_433_1469.n195 0.717707
R2601 a_433_1469.n303 a_433_1469.n302 0.717685
R2602 a_433_1469.n285 a_433_1469.n284 0.717685
R2603 a_433_1469.n283 a_433_1469.n281 0.687705
R2604 a_433_1469.n62 a_433_1469.n60 0.687705
R2605 a_433_1469.n289 a_433_1469.n288 0.674448
R2606 a_433_1469.n261 a_433_1469.n259 0.674448
R2607 a_433_1469.n189 a_433_1469.n188 0.674448
R2608 a_433_1469.n305 a_433_1469.n2 0.614136
R2609 a_433_1469.n45 a_433_1469.n37 0.614136
R2610 a_433_1469.n274 a_433_1469.n273 0.612242
R2611 a_433_1469.n53 a_433_1469.n52 0.612242
R2612 a_433_1469.n298 a_433_1469.n297 0.447105
R2613 a_433_1469.n220 a_433_1469.n219 0.3755
R2614 a_433_1469.n231 a_433_1469.n230 0.3755
R2615 a_433_1469.n242 a_433_1469.n241 0.3755
R2616 a_433_1469.n145 a_433_1469.n144 0.3755
R2617 a_433_1469.n156 a_433_1469.n155 0.3755
R2618 a_433_1469.n117 a_433_1469.n116 0.3755
R2619 a_433_1469.n106 a_433_1469.n105 0.3755
R2620 a_433_1469.n307 a_433_1469.n1 0.257202
R2621 a_433_1469.n254 a_433_1469.n253 0.257202
R2622 a_433_1469.n208 a_433_1469.n33 0.257202
R2623 a_433_1469.n202 a_433_1469.n201 0.257202
R2624 a_433_1469.n47 a_433_1469.n46 0.257202
R2625 a_433_1469.n276 a_433_1469.n275 0.25305
R2626 a_433_1469.n55 a_433_1469.n54 0.25305
R2627 a_433_1469.n268 a_433_1469.n267 0.24999
R2628 a_433_1469.n170 a_433_1469.n167 0.24999
R2629 a_433_1469.n167 a_433_1469.n127 0.192808
R2630 a_433_1469.n112 a_433_1469.n111 0.192808
R2631 a_433_1469.n225 a_433_1469.n224 0.190404
R2632 a_433_1469.n247 a_433_1469.n246 0.190404
R2633 a_433_1469.n203 a_433_1469.n202 0.188
R2634 a_433_1469.n208 a_433_1469.n207 0.188
R2635 a_433_1469.n209 a_433_1469.n208 0.188
R2636 a_433_1469.n214 a_433_1469.n213 0.188
R2637 a_433_1469.n215 a_433_1469.n214 0.188
R2638 a_433_1469.n236 a_433_1469.n235 0.188
R2639 a_433_1469.n237 a_433_1469.n236 0.188
R2640 a_433_1469.n253 a_433_1469.n252 0.188
R2641 a_433_1469.n253 a_433_1469.n12 0.188
R2642 a_433_1469.n8 a_433_1469.n1 0.188
R2643 a_433_1469.n293 a_433_1469.n1 0.188
R2644 a_433_1469.n150 a_433_1469.n149 0.188
R2645 a_433_1469.n151 a_433_1469.n150 0.188
R2646 a_433_1469.n161 a_433_1469.n160 0.188
R2647 a_433_1469.n162 a_433_1469.n161 0.188
R2648 a_433_1469.n123 a_433_1469.n122 0.188
R2649 a_433_1469.n122 a_433_1469.n121 0.188
R2650 a_433_1469.n226 a_433_1469.n225 0.185596
R2651 a_433_1469.n248 a_433_1469.n247 0.185596
R2652 a_433_1469.n167 a_433_1469.n166 0.183192
R2653 a_433_1469.n111 a_433_1469.n110 0.183192
R2654 a_433_1469.n203 a_433_1469.n34 0.173577
R2655 a_433_1469.n207 a_433_1469.n34 0.173577
R2656 a_433_1469.n209 a_433_1469.n31 0.173577
R2657 a_433_1469.n213 a_433_1469.n31 0.173577
R2658 a_433_1469.n215 a_433_1469.n28 0.173577
R2659 a_433_1469.n219 a_433_1469.n28 0.173577
R2660 a_433_1469.n220 a_433_1469.n26 0.173577
R2661 a_433_1469.n224 a_433_1469.n26 0.173577
R2662 a_433_1469.n226 a_433_1469.n23 0.173577
R2663 a_433_1469.n230 a_433_1469.n23 0.173577
R2664 a_433_1469.n231 a_433_1469.n21 0.173577
R2665 a_433_1469.n235 a_433_1469.n21 0.173577
R2666 a_433_1469.n237 a_433_1469.n18 0.173577
R2667 a_433_1469.n241 a_433_1469.n18 0.173577
R2668 a_433_1469.n242 a_433_1469.n16 0.173577
R2669 a_433_1469.n246 a_433_1469.n16 0.173577
R2670 a_433_1469.n248 a_433_1469.n13 0.173577
R2671 a_433_1469.n252 a_433_1469.n13 0.173577
R2672 a_433_1469.n12 a_433_1469.n6 0.173577
R2673 a_433_1469.n8 a_433_1469.n6 0.173577
R2674 a_433_1469.n293 a_433_1469.n291 0.173577
R2675 a_433_1469.n297 a_433_1469.n291 0.173577
R2676 a_433_1469.n140 a_433_1469.n138 0.173577
R2677 a_433_1469.n144 a_433_1469.n138 0.173577
R2678 a_433_1469.n145 a_433_1469.n136 0.173577
R2679 a_433_1469.n149 a_433_1469.n136 0.173577
R2680 a_433_1469.n151 a_433_1469.n133 0.173577
R2681 a_433_1469.n155 a_433_1469.n133 0.173577
R2682 a_433_1469.n156 a_433_1469.n131 0.173577
R2683 a_433_1469.n160 a_433_1469.n131 0.173577
R2684 a_433_1469.n162 a_433_1469.n128 0.173577
R2685 a_433_1469.n166 a_433_1469.n128 0.173577
R2686 a_433_1469.n127 a_433_1469.n89 0.173577
R2687 a_433_1469.n123 a_433_1469.n89 0.173577
R2688 a_433_1469.n121 a_433_1469.n92 0.173577
R2689 a_433_1469.n117 a_433_1469.n92 0.173577
R2690 a_433_1469.n116 a_433_1469.n94 0.173577
R2691 a_433_1469.n112 a_433_1469.n94 0.173577
R2692 a_433_1469.n110 a_433_1469.n97 0.173577
R2693 a_433_1469.n106 a_433_1469.n97 0.173577
R2694 a_433_1469.n105 a_433_1469.n99 0.173577
R2695 a_433_1469.n101 a_433_1469.n99 0.173577
R2696 a_433_1469.n306 a_433_1469.n0 0.121712
R2697 a_433_1469.n300 a_433_1469.n290 0.121712
R2698 a_433_1469.n301 a_433_1469.n289 0.121712
R2699 a_433_1469.n305 a_433_1469.n304 0.121712
R2700 a_433_1469.n273 a_433_1469.n2 0.121712
R2701 a_433_1469.n281 a_433_1469.n274 0.121712
R2702 a_433_1469.n272 a_433_1469.n271 0.121712
R2703 a_433_1469.n259 a_433_1469.n5 0.121712
R2704 a_433_1469.n258 a_433_1469.n257 0.121712
R2705 a_433_1469.n194 a_433_1469.n189 0.121712
R2706 a_433_1469.n193 a_433_1469.n190 0.121712
R2707 a_433_1469.n197 a_433_1469.n37 0.121712
R2708 a_433_1469.n52 a_433_1469.n45 0.121712
R2709 a_433_1469.n60 a_433_1469.n53 0.121712
R2710 a_433_1469.n198 a_433_1469.n36 0.121712
R2711 a_433_1469.n51 a_433_1469.n50 0.121712
R2712 a_433_1469.n280 a_433_1469.n279 0.117924
R2713 a_433_1469.n59 a_433_1469.n58 0.117924
R2714 a_433_1469.n171 a_433_1469.n88 0.06917
R2715 a_433_1469.n171 a_433_1469.n170 0.0676037
R2716 a_433_1469.n280 a_433_1469.n276 0.0194394
R2717 a_433_1469.n59 a_433_1469.n55 0.0194394
R2718 a_433_1469.n307 a_433_1469.n306 0.00807576
R2719 a_433_1469.n298 a_433_1469.n290 0.00807576
R2720 a_433_1469.n272 a_433_1469.n268 0.00807576
R2721 a_433_1469.n258 a_433_1469.n254 0.00807576
R2722 a_433_1469.n190 a_433_1469.n33 0.00807576
R2723 a_433_1469.n201 a_433_1469.n36 0.00807576
R2724 a_433_1469.n51 a_433_1469.n47 0.00807576
C10 VBIAS VGND 7.56106f
C11 D2 VGND 5.61092f
C12 D1 VGND 1.82994f
C13 VINM VGND 2.18055f
C14 VINP VGND 1.96766f
C15 a_433_1469.n0 VGND 0.01701f
C16 a_433_1469.n1 VGND 0.01977f
C17 a_433_1469.n2 VGND 0.03648f
C18 a_433_1469.n3 VGND 0.07723f
C19 a_433_1469.n4 VGND 0.10474f
C20 a_433_1469.n5 VGND 0.07537f
C21 a_433_1469.n6 VGND 0.01067f
C22 a_433_1469.n7 VGND 0.00698f
C23 a_433_1469.t106 VGND 0.10828f
C24 a_433_1469.n8 VGND 0.01111f
C25 a_433_1469.n9 VGND 0.01011f
C26 a_433_1469.n10 VGND 0.08205f
C27 a_433_1469.n11 VGND 0.00408f
C28 a_433_1469.n12 VGND 0.01715f
C29 a_433_1469.n13 VGND 0.01067f
C30 a_433_1469.t103 VGND 0.10828f
C31 a_433_1469.n14 VGND 0.08205f
C32 a_433_1469.t105 VGND 0.01425f
C33 a_433_1469.t102 VGND 0.01425f
C34 a_433_1469.n15 VGND 0.02925f
C35 a_433_1469.n16 VGND 0.01067f
C36 a_433_1469.t100 VGND 0.10828f
C37 a_433_1469.n17 VGND 0.08205f
C38 a_433_1469.n18 VGND 0.01067f
C39 a_433_1469.t97 VGND 0.10828f
C40 a_433_1469.n19 VGND 0.08205f
C41 a_433_1469.t99 VGND 0.01425f
C42 a_433_1469.t96 VGND 0.01425f
C43 a_433_1469.n20 VGND 0.02925f
C44 a_433_1469.n21 VGND 0.01067f
C45 a_433_1469.t94 VGND 0.10828f
C46 a_433_1469.n22 VGND 0.08205f
C47 a_433_1469.n23 VGND 0.01067f
C48 a_433_1469.t91 VGND 0.10828f
C49 a_433_1469.n24 VGND 0.08205f
C50 a_433_1469.t93 VGND 0.01425f
C51 a_433_1469.t90 VGND 0.01425f
C52 a_433_1469.n25 VGND 0.02925f
C53 a_433_1469.n26 VGND 0.01067f
C54 a_433_1469.t88 VGND 0.10828f
C55 a_433_1469.n27 VGND 0.08205f
C56 a_433_1469.n28 VGND 0.01067f
C57 a_433_1469.t85 VGND 0.10828f
C58 a_433_1469.n29 VGND 0.08205f
C59 a_433_1469.t87 VGND 0.01425f
C60 a_433_1469.t84 VGND 0.01425f
C61 a_433_1469.n30 VGND 0.02925f
C62 a_433_1469.n31 VGND 0.01067f
C63 a_433_1469.t82 VGND 0.10828f
C64 a_433_1469.n32 VGND 0.08205f
C65 a_433_1469.n33 VGND 0.01426f
C66 a_433_1469.n34 VGND 0.01067f
C67 a_433_1469.t79 VGND 0.10828f
C68 a_433_1469.n35 VGND 0.08205f
C69 a_433_1469.n36 VGND 0.00639f
C70 a_433_1469.n37 VGND 0.03648f
C71 a_433_1469.n38 VGND 0.28406f
C72 a_433_1469.n39 VGND 0.10218f
C73 a_433_1469.t78 VGND 0.04824f
C74 a_433_1469.n40 VGND 0.15875f
C75 a_433_1469.t66 VGND 0.04824f
C76 a_433_1469.n41 VGND 0.12141f
C77 a_433_1469.t54 VGND 0.04824f
C78 a_433_1469.n42 VGND 0.12198f
C79 a_433_1469.t18 VGND 0.04824f
C80 a_433_1469.n43 VGND 0.16873f
C81 a_433_1469.n44 VGND 0.28744f
C82 a_433_1469.n45 VGND 0.03648f
C83 a_433_1469.t67 VGND 0.16823f
C84 a_433_1469.t64 VGND 0.16823f
C85 a_433_1469.n46 VGND 0.18118f
C86 a_433_1469.n47 VGND 0.01426f
C87 a_433_1469.t69 VGND 0.01425f
C88 a_433_1469.t65 VGND 0.01425f
C89 a_433_1469.n48 VGND 0.02849f
C90 a_433_1469.n49 VGND 0.00567f
C91 a_433_1469.n50 VGND 0.01701f
C92 a_433_1469.n51 VGND 0.00639f
C93 a_433_1469.n52 VGND 0.03639f
C94 a_433_1469.n53 VGND 0.0364f
C95 a_433_1469.t55 VGND 0.16823f
C96 a_433_1469.t52 VGND 0.16824f
C97 a_433_1469.n54 VGND 0.18096f
C98 a_433_1469.n55 VGND 0.01436f
C99 a_433_1469.t57 VGND 0.01425f
C100 a_433_1469.t53 VGND 0.01425f
C101 a_433_1469.n56 VGND 0.02849f
C102 a_433_1469.n57 VGND 0.00567f
C103 a_433_1469.n58 VGND 0.0172f
C104 a_433_1469.n59 VGND 0.00677f
C105 a_433_1469.n60 VGND 0.04042f
C106 a_433_1469.t21 VGND 0.01425f
C107 a_433_1469.t17 VGND 0.01425f
C108 a_433_1469.n61 VGND 0.03001f
C109 a_433_1469.n62 VGND 0.15529f
C110 a_433_1469.n63 VGND 0.06044f
C111 a_433_1469.t41 VGND 0.01425f
C112 a_433_1469.t38 VGND 0.01425f
C113 a_433_1469.n64 VGND 0.03001f
C114 a_433_1469.n65 VGND 0.15856f
C115 a_433_1469.t114 VGND 0.01425f
C116 a_433_1469.t113 VGND 0.01425f
C117 a_433_1469.n66 VGND 0.03001f
C118 a_433_1469.n67 VGND 0.11178f
C119 a_433_1469.t14 VGND 0.01425f
C120 a_433_1469.t13 VGND 0.01425f
C121 a_433_1469.n68 VGND 0.03001f
C122 a_433_1469.n69 VGND 0.11158f
C123 a_433_1469.t101 VGND 0.01425f
C124 a_433_1469.t98 VGND 0.01425f
C125 a_433_1469.n70 VGND 0.03001f
C126 a_433_1469.n71 VGND 0.14842f
C127 a_433_1469.n72 VGND 0.10079f
C128 a_433_1469.n73 VGND 0.08899f
C129 a_433_1469.t7 VGND 0.01425f
C130 a_433_1469.t6 VGND 0.01425f
C131 a_433_1469.n74 VGND 0.03065f
C132 a_433_1469.t3 VGND 0.01425f
C133 a_433_1469.t2 VGND 0.01425f
C134 a_433_1469.n75 VGND 0.03001f
C135 a_433_1469.n76 VGND 0.25091f
C136 a_433_1469.t5 VGND 0.01425f
C137 a_433_1469.t4 VGND 0.01425f
C138 a_433_1469.n77 VGND 0.03065f
C139 a_433_1469.t1 VGND 0.01425f
C140 a_433_1469.t0 VGND 0.01425f
C141 a_433_1469.n78 VGND 0.03001f
C142 a_433_1469.n79 VGND 0.25062f
C143 a_433_1469.n80 VGND 0.33583f
C144 a_433_1469.n81 VGND 0.09549f
C145 a_433_1469.t95 VGND 0.01425f
C146 a_433_1469.t92 VGND 0.01425f
C147 a_433_1469.n82 VGND 0.03001f
C148 a_433_1469.n83 VGND 0.14806f
C149 a_433_1469.t12 VGND 0.01425f
C150 a_433_1469.t119 VGND 0.01425f
C151 a_433_1469.n84 VGND 0.02914f
C152 a_433_1469.n85 VGND 0.0683f
C153 a_433_1469.t112 VGND 0.01425f
C154 a_433_1469.t11 VGND 0.01425f
C155 a_433_1469.n86 VGND 0.02913f
C156 a_433_1469.n87 VGND 0.05584f
C157 a_433_1469.n88 VGND 0.03468f
C158 a_433_1469.n89 VGND 0.01067f
C159 a_433_1469.n90 VGND 0.00698f
C160 a_433_1469.t34 VGND 0.10828f
C161 a_433_1469.t39 VGND 0.01425f
C162 a_433_1469.t35 VGND 0.01425f
C163 a_433_1469.n91 VGND 0.02925f
C164 a_433_1469.n92 VGND 0.01067f
C165 a_433_1469.n93 VGND 0.00698f
C166 a_433_1469.t37 VGND 0.10828f
C167 a_433_1469.n94 VGND 0.01067f
C168 a_433_1469.n95 VGND 0.00698f
C169 a_433_1469.t40 VGND 0.10828f
C170 a_433_1469.t45 VGND 0.01425f
C171 a_433_1469.t42 VGND 0.01425f
C172 a_433_1469.n96 VGND 0.02925f
C173 a_433_1469.n97 VGND 0.01067f
C174 a_433_1469.n98 VGND 0.00698f
C175 a_433_1469.t43 VGND 0.10828f
C176 a_433_1469.n99 VGND 0.01067f
C177 a_433_1469.n100 VGND 0.00698f
C178 a_433_1469.t46 VGND 0.10828f
C179 a_433_1469.t49 VGND 0.16843f
C180 a_433_1469.n101 VGND 0.10317f
C181 a_433_1469.n102 VGND 0.01011f
C182 a_433_1469.n103 VGND 0.08205f
C183 a_433_1469.n104 VGND 0.00408f
C184 a_433_1469.n105 VGND 0.02292f
C185 a_433_1469.n106 VGND 0.01689f
C186 a_433_1469.n107 VGND 0.01011f
C187 a_433_1469.n108 VGND 0.08205f
C188 a_433_1469.n109 VGND 0.00408f
C189 a_433_1469.n110 VGND 0.017f
C190 a_433_1469.n111 VGND 0.05618f
C191 a_433_1469.n112 VGND 0.01126f
C192 a_433_1469.n113 VGND 0.01011f
C193 a_433_1469.n114 VGND 0.08205f
C194 a_433_1469.n115 VGND 0.00408f
C195 a_433_1469.n116 VGND 0.02292f
C196 a_433_1469.n117 VGND 0.01689f
C197 a_433_1469.n118 VGND 0.01011f
C198 a_433_1469.n119 VGND 0.08205f
C199 a_433_1469.n120 VGND 0.00408f
C200 a_433_1469.n121 VGND 0.01715f
C201 a_433_1469.n122 VGND 0.05618f
C202 a_433_1469.n123 VGND 0.01111f
C203 a_433_1469.n124 VGND 0.01011f
C204 a_433_1469.n125 VGND 0.08205f
C205 a_433_1469.n126 VGND 0.00408f
C206 a_433_1469.n127 VGND 0.01729f
C207 a_433_1469.n128 VGND 0.01067f
C208 a_433_1469.t31 VGND 0.10828f
C209 a_433_1469.n129 VGND 0.08205f
C210 a_433_1469.t32 VGND 0.01425f
C211 a_433_1469.t29 VGND 0.01425f
C212 a_433_1469.n130 VGND 0.02925f
C213 a_433_1469.n131 VGND 0.01067f
C214 a_433_1469.t28 VGND 0.10828f
C215 a_433_1469.n132 VGND 0.08205f
C216 a_433_1469.n133 VGND 0.01067f
C217 a_433_1469.t25 VGND 0.10828f
C218 a_433_1469.n134 VGND 0.08205f
C219 a_433_1469.t26 VGND 0.01425f
C220 a_433_1469.t23 VGND 0.01425f
C221 a_433_1469.n135 VGND 0.02925f
C222 a_433_1469.n136 VGND 0.01067f
C223 a_433_1469.t22 VGND 0.10828f
C224 a_433_1469.n137 VGND 0.08205f
C225 a_433_1469.n138 VGND 0.01067f
C226 a_433_1469.t19 VGND 0.10828f
C227 a_433_1469.n139 VGND 0.08205f
C228 a_433_1469.t16 VGND 0.16843f
C229 a_433_1469.n140 VGND 0.10921f
C230 a_433_1469.n141 VGND 0.00408f
C231 a_433_1469.n142 VGND 0.00698f
C232 a_433_1469.n143 VGND 0.01011f
C233 a_433_1469.n144 VGND 0.01689f
C234 a_433_1469.n145 VGND 0.02292f
C235 a_433_1469.n146 VGND 0.00408f
C236 a_433_1469.n147 VGND 0.00698f
C237 a_433_1469.n148 VGND 0.01011f
C238 a_433_1469.n149 VGND 0.01111f
C239 a_433_1469.n150 VGND 0.05618f
C240 a_433_1469.n151 VGND 0.01715f
C241 a_433_1469.n152 VGND 0.00408f
C242 a_433_1469.n153 VGND 0.00698f
C243 a_433_1469.n154 VGND 0.01011f
C244 a_433_1469.n155 VGND 0.01689f
C245 a_433_1469.n156 VGND 0.02292f
C246 a_433_1469.n157 VGND 0.00408f
C247 a_433_1469.n158 VGND 0.00698f
C248 a_433_1469.n159 VGND 0.01011f
C249 a_433_1469.n160 VGND 0.01111f
C250 a_433_1469.n161 VGND 0.05618f
C251 a_433_1469.n162 VGND 0.01715f
C252 a_433_1469.n163 VGND 0.00408f
C253 a_433_1469.n164 VGND 0.00698f
C254 a_433_1469.n165 VGND 0.01011f
C255 a_433_1469.n166 VGND 0.01096f
C256 a_433_1469.n167 VGND 0.01956f
C257 a_433_1469.t36 VGND 0.01425f
C258 a_433_1469.t33 VGND 0.01425f
C259 a_433_1469.n168 VGND 0.02849f
C260 a_433_1469.n169 VGND 0.00567f
C261 a_433_1469.n170 VGND 0.0197f
C262 a_433_1469.n171 VGND 0.05761f
C263 a_433_1469.n172 VGND 0.14513f
C264 a_433_1469.t89 VGND 0.01425f
C265 a_433_1469.t86 VGND 0.01425f
C266 a_433_1469.n173 VGND 0.03001f
C267 a_433_1469.n174 VGND 0.14849f
C268 a_433_1469.t118 VGND 0.01425f
C269 a_433_1469.t117 VGND 0.01425f
C270 a_433_1469.n175 VGND 0.03001f
C271 a_433_1469.n176 VGND 0.11106f
C272 a_433_1469.t10 VGND 0.01425f
C273 a_433_1469.t9 VGND 0.01425f
C274 a_433_1469.n177 VGND 0.03001f
C275 a_433_1469.n178 VGND 0.11184f
C276 a_433_1469.t30 VGND 0.01425f
C277 a_433_1469.t27 VGND 0.01425f
C278 a_433_1469.n179 VGND 0.03001f
C279 a_433_1469.n180 VGND 0.15856f
C280 a_433_1469.n181 VGND 0.10452f
C281 a_433_1469.n182 VGND 0.08252f
C282 a_433_1469.t24 VGND 0.01425f
C283 a_433_1469.t20 VGND 0.01425f
C284 a_433_1469.n183 VGND 0.03001f
C285 a_433_1469.n184 VGND 0.15856f
C286 a_433_1469.t8 VGND 0.01425f
C287 a_433_1469.t56 VGND 0.01425f
C288 a_433_1469.n185 VGND 0.03001f
C289 a_433_1469.n186 VGND 0.11184f
C290 a_433_1469.t116 VGND 0.01425f
C291 a_433_1469.t68 VGND 0.01425f
C292 a_433_1469.n187 VGND 0.03001f
C293 a_433_1469.n188 VGND 0.10777f
C294 a_433_1469.n189 VGND 0.03977f
C295 a_433_1469.n190 VGND 0.00639f
C296 a_433_1469.t83 VGND 0.01425f
C297 a_433_1469.t80 VGND 0.01425f
C298 a_433_1469.n191 VGND 0.02849f
C299 a_433_1469.n192 VGND 0.00567f
C300 a_433_1469.n193 VGND 0.01701f
C301 a_433_1469.n194 VGND 0.07537f
C302 a_433_1469.n195 VGND 0.07804f
C303 a_433_1469.n196 VGND 0.0553f
C304 a_433_1469.n197 VGND 0.07537f
C305 a_433_1469.n198 VGND 0.01701f
C306 a_433_1469.t81 VGND 0.01425f
C307 a_433_1469.t77 VGND 0.01425f
C308 a_433_1469.n199 VGND 0.02849f
C309 a_433_1469.n200 VGND 0.00567f
C310 a_433_1469.n201 VGND 0.01426f
C311 a_433_1469.t76 VGND 0.16823f
C312 a_433_1469.n202 VGND 0.10048f
C313 a_433_1469.n203 VGND 0.01715f
C314 a_433_1469.n204 VGND 0.00408f
C315 a_433_1469.n205 VGND 0.00698f
C316 a_433_1469.n206 VGND 0.01011f
C317 a_433_1469.n207 VGND 0.01111f
C318 a_433_1469.n208 VGND 0.01977f
C319 a_433_1469.n209 VGND 0.01715f
C320 a_433_1469.n210 VGND 0.00408f
C321 a_433_1469.n211 VGND 0.00698f
C322 a_433_1469.n212 VGND 0.01011f
C323 a_433_1469.n213 VGND 0.01111f
C324 a_433_1469.n214 VGND 0.05677f
C325 a_433_1469.n215 VGND 0.01715f
C326 a_433_1469.n216 VGND 0.00408f
C327 a_433_1469.n217 VGND 0.00698f
C328 a_433_1469.n218 VGND 0.01011f
C329 a_433_1469.n219 VGND 0.01689f
C330 a_433_1469.n220 VGND 0.02292f
C331 a_433_1469.n221 VGND 0.00408f
C332 a_433_1469.n222 VGND 0.00698f
C333 a_433_1469.n223 VGND 0.01011f
C334 a_433_1469.n224 VGND 0.01119f
C335 a_433_1469.n225 VGND 0.05677f
C336 a_433_1469.n226 VGND 0.01707f
C337 a_433_1469.n227 VGND 0.00408f
C338 a_433_1469.n228 VGND 0.00698f
C339 a_433_1469.n229 VGND 0.01011f
C340 a_433_1469.n230 VGND 0.01689f
C341 a_433_1469.n231 VGND 0.02292f
C342 a_433_1469.n232 VGND 0.00408f
C343 a_433_1469.n233 VGND 0.00698f
C344 a_433_1469.n234 VGND 0.01011f
C345 a_433_1469.n235 VGND 0.01111f
C346 a_433_1469.n236 VGND 0.05677f
C347 a_433_1469.n237 VGND 0.01715f
C348 a_433_1469.n238 VGND 0.00408f
C349 a_433_1469.n239 VGND 0.00698f
C350 a_433_1469.n240 VGND 0.01011f
C351 a_433_1469.n241 VGND 0.01689f
C352 a_433_1469.n242 VGND 0.02292f
C353 a_433_1469.n243 VGND 0.00408f
C354 a_433_1469.n244 VGND 0.00698f
C355 a_433_1469.n245 VGND 0.01011f
C356 a_433_1469.n246 VGND 0.01119f
C357 a_433_1469.n247 VGND 0.05677f
C358 a_433_1469.n248 VGND 0.01707f
C359 a_433_1469.n249 VGND 0.00408f
C360 a_433_1469.n250 VGND 0.00698f
C361 a_433_1469.n251 VGND 0.01011f
C362 a_433_1469.n252 VGND 0.01111f
C363 a_433_1469.n253 VGND 0.01977f
C364 a_433_1469.n254 VGND 0.01426f
C365 a_433_1469.t108 VGND 0.01425f
C366 a_433_1469.t104 VGND 0.01425f
C367 a_433_1469.n255 VGND 0.02849f
C368 a_433_1469.n256 VGND 0.00567f
C369 a_433_1469.n257 VGND 0.01701f
C370 a_433_1469.n258 VGND 0.00639f
C371 a_433_1469.n259 VGND 0.03977f
C372 a_433_1469.t72 VGND 0.01425f
C373 a_433_1469.t15 VGND 0.01425f
C374 a_433_1469.n260 VGND 0.03001f
C375 a_433_1469.n261 VGND 0.10777f
C376 a_433_1469.t60 VGND 0.01425f
C377 a_433_1469.t115 VGND 0.01425f
C378 a_433_1469.n262 VGND 0.03001f
C379 a_433_1469.n263 VGND 0.11184f
C380 a_433_1469.t48 VGND 0.01425f
C381 a_433_1469.t44 VGND 0.01425f
C382 a_433_1469.n264 VGND 0.03001f
C383 a_433_1469.n265 VGND 0.15856f
C384 a_433_1469.n266 VGND 0.08237f
C385 a_433_1469.t73 VGND 0.16823f
C386 a_433_1469.t70 VGND 0.16823f
C387 a_433_1469.n267 VGND 0.18097f
C388 a_433_1469.n268 VGND 0.01403f
C389 a_433_1469.t74 VGND 0.01425f
C390 a_433_1469.t71 VGND 0.01425f
C391 a_433_1469.n269 VGND 0.02849f
C392 a_433_1469.n270 VGND 0.00567f
C393 a_433_1469.n271 VGND 0.01701f
C394 a_433_1469.n272 VGND 0.00639f
C395 a_433_1469.n273 VGND 0.03639f
C396 a_433_1469.n274 VGND 0.0364f
C397 a_433_1469.t61 VGND 0.16823f
C398 a_433_1469.t58 VGND 0.16823f
C399 a_433_1469.n275 VGND 0.18093f
C400 a_433_1469.n276 VGND 0.01436f
C401 a_433_1469.t62 VGND 0.01425f
C402 a_433_1469.t59 VGND 0.01425f
C403 a_433_1469.n277 VGND 0.02849f
C404 a_433_1469.n278 VGND 0.00567f
C405 a_433_1469.n279 VGND 0.0172f
C406 a_433_1469.n280 VGND 0.00677f
C407 a_433_1469.n281 VGND 0.04042f
C408 a_433_1469.t50 VGND 0.01425f
C409 a_433_1469.t47 VGND 0.01425f
C410 a_433_1469.n282 VGND 0.03001f
C411 a_433_1469.n283 VGND 0.15529f
C412 a_433_1469.n284 VGND 0.06022f
C413 a_433_1469.n285 VGND 0.28447f
C414 a_433_1469.t51 VGND 0.04824f
C415 a_433_1469.n286 VGND 0.16883f
C416 a_433_1469.t63 VGND 0.04824f
C417 a_433_1469.n287 VGND 0.12211f
C418 a_433_1469.t75 VGND 0.04824f
C419 a_433_1469.n288 VGND 0.11804f
C420 a_433_1469.n289 VGND 0.03977f
C421 a_433_1469.n290 VGND 0.00639f
C422 a_433_1469.n291 VGND 0.01067f
C423 a_433_1469.t109 VGND 0.10828f
C424 a_433_1469.n292 VGND 0.08205f
C425 a_433_1469.n293 VGND 0.01715f
C426 a_433_1469.n294 VGND 0.00408f
C427 a_433_1469.n295 VGND 0.00698f
C428 a_433_1469.n296 VGND 0.01011f
C429 a_433_1469.n297 VGND 0.02149f
C430 a_433_1469.n298 VGND 0.02188f
C431 a_433_1469.t111 VGND 0.04595f
C432 a_433_1469.n299 VGND 0.01671f
C433 a_433_1469.n300 VGND 0.01701f
C434 a_433_1469.n301 VGND 0.07537f
C435 a_433_1469.n302 VGND 0.27955f
C436 a_433_1469.n303 VGND 0.0553f
C437 a_433_1469.n304 VGND 0.07537f
C438 a_433_1469.n305 VGND 0.03648f
C439 a_433_1469.n306 VGND 0.00639f
C440 a_433_1469.n307 VGND 0.01426f
C441 a_433_1469.n308 VGND 0.00567f
C442 a_433_1469.t107 VGND 0.01425f
C443 a_433_1469.n309 VGND 0.02849f
C444 a_433_1469.t110 VGND 0.01425f
C445 VINP.n0 VGND 0.01242f
C446 VINP.n1 VGND 0.01072f
C447 VINP.n2 VGND 0.01243f
C448 VINP.t7 VGND 0.19289f
C449 VINP.n3 VGND 0.02412f
C450 VINP.n4 VGND 0.01243f
C451 VINP.t6 VGND 0.19289f
C452 VINP.n5 VGND 0.02412f
C453 VINP.n6 VGND 0.01243f
C454 VINP.t5 VGND 0.19289f
C455 VINP.n7 VGND 0.01274f
C456 VINP.n8 VGND 0.01243f
C457 VINP.t4 VGND 0.19289f
C458 VINP.n9 VGND 0.01072f
C459 VINP.n10 VGND 0.01274f
C460 VINP.n11 VGND 0.01072f
C461 VINP.n12 VGND 0.01243f
C462 VINP.t3 VGND 0.19289f
C463 VINP.n13 VGND 0.02412f
C464 VINP.n14 VGND 0.01243f
C465 VINP.t2 VGND 0.19289f
C466 VINP.n15 VGND 0.02412f
C467 VINP.n16 VGND 0.01243f
C468 VINP.t1 VGND 0.19289f
C469 VINP.t0 VGND 0.29995f
C470 VINP.n17 VGND 0.21017f
C471 VINP.n18 VGND 0.01801f
C472 VINP.n19 VGND 0.14617f
C473 VINP.n20 VGND 0.00726f
C474 VINP.n21 VGND 0.04894f
C475 VINP.n22 VGND 0.03819f
C476 VINP.n23 VGND 0.01801f
C477 VINP.n24 VGND 0.14617f
C478 VINP.n25 VGND 0.00726f
C479 VINP.n26 VGND 0.04894f
C480 VINP.n27 VGND 0.03434f
C481 VINP.n28 VGND 0.01801f
C482 VINP.n29 VGND 0.14617f
C483 VINP.n30 VGND 0.00733f
C484 VINP.n31 VGND 0.03684f
C485 VINP.n32 VGND 0.13547f
C486 VINP.n33 VGND 0.13622f
C487 VINP.n34 VGND 0.02458f
C488 VINP.n35 VGND 0.01805f
C489 VINP.n36 VGND 0.14617f
C490 VINP.n37 VGND 0.00726f
C491 VINP.n38 VGND 0.04743f
C492 VINP.n39 VGND 0.03819f
C493 VINP.n40 VGND 0.01801f
C494 VINP.n41 VGND 0.14617f
C495 VINP.n42 VGND 0.00726f
C496 VINP.n43 VGND 0.04894f
C497 VINP.n44 VGND 0.03819f
C498 VINP.n45 VGND 0.01801f
C499 VINP.n46 VGND 0.14617f
C500 VINP.n47 VGND 0.00726f
C501 VINP.n48 VGND 0.04894f
C502 VINP.n49 VGND 0.04459f
C503 VINP.n50 VGND 0.00726f
C504 VINP.n51 VGND 0.14617f
C505 VINP.n52 VGND 0.01812f
C506 VINP.n53 VGND 0.02761f
C507 VINP.n54 VGND 0.13256f
C508 VINM.n0 VGND 0.02456f
C509 VINM.n1 VGND 0.0099f
C510 VINM.n2 VGND 0.01148f
C511 VINM.t4 VGND 0.17818f
C512 VINM.n3 VGND 0.01674f
C513 VINM.n4 VGND 0.13502f
C514 VINM.n5 VGND 0.00678f
C515 VINM.n6 VGND 0.03451f
C516 VINM.n7 VGND 0.0559f
C517 VINM.n8 VGND 0.11835f
C518 VINM.n9 VGND 0.0247f
C519 VINM.n10 VGND 0.0099f
C520 VINM.n11 VGND 0.01148f
C521 VINM.t5 VGND 0.17818f
C522 VINM.n12 VGND 0.02423f
C523 VINM.n13 VGND 0.01674f
C524 VINM.n14 VGND 0.13502f
C525 VINM.n15 VGND 0.00678f
C526 VINM.n16 VGND 0.03419f
C527 VINM.n17 VGND 0.0247f
C528 VINM.n18 VGND 0.04695f
C529 VINM.n19 VGND 0.04695f
C530 VINM.n20 VGND 0.0247f
C531 VINM.n21 VGND 0.0099f
C532 VINM.n22 VGND 0.01148f
C533 VINM.t6 VGND 0.17818f
C534 VINM.n23 VGND 0.0244f
C535 VINM.n24 VGND 0.01675f
C536 VINM.n25 VGND 0.13502f
C537 VINM.n26 VGND 0.00678f
C538 VINM.n27 VGND 0.03401f
C539 VINM.n28 VGND 0.0247f
C540 VINM.n29 VGND 0.04555f
C541 VINM.n30 VGND 0.04555f
C542 VINM.n31 VGND 0.0247f
C543 VINM.n32 VGND 0.0099f
C544 VINM.n33 VGND 0.01148f
C545 VINM.t7 VGND 0.17818f
C546 VINM.n34 VGND 0.03401f
C547 VINM.n35 VGND 0.00678f
C548 VINM.n36 VGND 0.13502f
C549 VINM.n37 VGND 0.01675f
C550 VINM.n38 VGND 0.0244f
C551 VINM.n39 VGND 0.0247f
C552 VINM.n40 VGND 0.10795f
C553 VINM.n41 VGND 0.10818f
C554 VINM.n42 VGND 0.0247f
C555 VINM.n43 VGND 0.0099f
C556 VINM.n44 VGND 0.01148f
C557 VINM.t0 VGND 0.17818f
C558 VINM.n45 VGND 0.02429f
C559 VINM.n46 VGND 0.01675f
C560 VINM.n47 VGND 0.13502f
C561 VINM.n48 VGND 0.00678f
C562 VINM.n49 VGND 0.03413f
C563 VINM.n50 VGND 0.0247f
C564 VINM.n51 VGND 0.04617f
C565 VINM.n52 VGND 0.04617f
C566 VINM.n53 VGND 0.0247f
C567 VINM.n54 VGND 0.0099f
C568 VINM.n55 VGND 0.01148f
C569 VINM.t1 VGND 0.17818f
C570 VINM.n56 VGND 0.02417f
C571 VINM.n57 VGND 0.01674f
C572 VINM.n58 VGND 0.13502f
C573 VINM.n59 VGND 0.00679f
C574 VINM.n60 VGND 0.03425f
C575 VINM.n61 VGND 0.0247f
C576 VINM.n62 VGND 0.04648f
C577 VINM.n63 VGND 0.04648f
C578 VINM.n64 VGND 0.0247f
C579 VINM.n65 VGND 0.0099f
C580 VINM.n66 VGND 0.01148f
C581 VINM.t2 VGND 0.17818f
C582 VINM.n67 VGND 0.02417f
C583 VINM.n68 VGND 0.01674f
C584 VINM.n69 VGND 0.13502f
C585 VINM.n70 VGND 0.00679f
C586 VINM.n71 VGND 0.03425f
C587 VINM.n72 VGND 0.0247f
C588 VINM.n73 VGND 0.04648f
C589 VINM.n74 VGND 0.04648f
C590 VINM.n75 VGND 0.0247f
C591 VINM.n76 VGND 0.0099f
C592 VINM.n77 VGND 0.01148f
C593 VINM.t3 VGND 0.17818f
C594 VINM.n78 VGND 0.02417f
C595 VINM.n79 VGND 0.01674f
C596 VINM.n80 VGND 0.13502f
C597 VINM.n81 VGND 0.00679f
C598 VINM.n82 VGND 0.03425f
C599 VINM.n83 VGND 0.0247f
C600 VINM.n84 VGND 0.19719f
C601 D1.t3 VGND 0.04193f
C602 D1.t2 VGND 0.04193f
C603 D1.n0 VGND 0.10661f
C604 D1.n1 VGND 1.17842f
C605 D1.t7 VGND 0.04193f
C606 D1.t5 VGND 0.04193f
C607 D1.n2 VGND 0.10661f
C608 D1.n3 VGND 2.04003f
C609 D1.t1 VGND 0.04193f
C610 D1.t0 VGND 0.04193f
C611 D1.n4 VGND 0.10496f
C612 D1.n5 VGND 1.95556f
C613 D1.t6 VGND 0.04193f
C614 D1.t4 VGND 0.04193f
C615 D1.n6 VGND 0.10496f
C616 D1.n7 VGND 1.48382f
C617 D1.n8 VGND 1.37628f
C618 D2.t2 VGND 0.02946f
C619 D2.t0 VGND 0.02946f
C620 D2.n0 VGND 0.07757f
C621 D2.n1 VGND 1.10713f
C622 D2.t3 VGND 0.02946f
C623 D2.t5 VGND 0.02946f
C624 D2.n2 VGND 0.07757f
C625 D2.n3 VGND 1.59189f
C626 D2.t7 VGND 0.02946f
C627 D2.t6 VGND 0.02946f
C628 D2.n4 VGND 0.07634f
C629 D2.n5 VGND 1.58364f
C630 D2.t4 VGND 0.02946f
C631 D2.t1 VGND 0.02946f
C632 D2.n6 VGND 0.07602f
C633 D2.n7 VGND 0.99665f
C634 D2.n8 VGND 1.08676f
C635 VBIAS.n0 VGND 0.00182f
C636 VBIAS.n1 VGND 0.00157f
C637 VBIAS.n2 VGND 0.00182f
C638 VBIAS.t23 VGND 0.0283f
C639 VBIAS.n3 VGND 0.00279f
C640 VBIAS.n4 VGND 0.00182f
C641 VBIAS.t22 VGND 0.0283f
C642 VBIAS.n5 VGND 0.00279f
C643 VBIAS.n6 VGND 0.00182f
C644 VBIAS.t2 VGND 0.0283f
C645 VBIAS.t9 VGND 0.00372f
C646 VBIAS.t3 VGND 0.00372f
C647 VBIAS.n7 VGND 0.00765f
C648 VBIAS.n8 VGND 0.00279f
C649 VBIAS.n9 VGND 0.00182f
C650 VBIAS.t8 VGND 0.0283f
C651 VBIAS.n10 VGND 0.00279f
C652 VBIAS.n11 VGND 0.00182f
C653 VBIAS.t4 VGND 0.0283f
C654 VBIAS.t7 VGND 0.00372f
C655 VBIAS.t5 VGND 0.00372f
C656 VBIAS.n12 VGND 0.00765f
C657 VBIAS.n13 VGND 0.00279f
C658 VBIAS.n14 VGND 0.00182f
C659 VBIAS.t6 VGND 0.0283f
C660 VBIAS.n15 VGND 0.00279f
C661 VBIAS.n16 VGND 0.00182f
C662 VBIAS.t21 VGND 0.0283f
C663 VBIAS.t20 VGND 0.04403f
C664 VBIAS.n17 VGND 0.02696f
C665 VBIAS.n18 VGND 0.00264f
C666 VBIAS.n19 VGND 0.02145f
C667 VBIAS.n20 VGND 0.00107f
C668 VBIAS.n21 VGND 0.00599f
C669 VBIAS.n22 VGND 0.00442f
C670 VBIAS.n23 VGND 0.00264f
C671 VBIAS.n24 VGND 0.02145f
C672 VBIAS.n25 VGND 0.00107f
C673 VBIAS.n26 VGND 0.00452f
C674 VBIAS.n27 VGND 0.01456f
C675 VBIAS.n28 VGND 0.00287f
C676 VBIAS.n29 VGND 0.00264f
C677 VBIAS.n30 VGND 0.02145f
C678 VBIAS.n31 VGND 0.00107f
C679 VBIAS.n32 VGND 0.00599f
C680 VBIAS.n33 VGND 0.00442f
C681 VBIAS.n34 VGND 0.00264f
C682 VBIAS.n35 VGND 0.02145f
C683 VBIAS.n36 VGND 0.00107f
C684 VBIAS.n37 VGND 0.00452f
C685 VBIAS.n38 VGND 0.01456f
C686 VBIAS.n39 VGND 0.00287f
C687 VBIAS.n40 VGND 0.00264f
C688 VBIAS.n41 VGND 0.02145f
C689 VBIAS.n42 VGND 0.00107f
C690 VBIAS.n43 VGND 0.00599f
C691 VBIAS.n44 VGND 0.00442f
C692 VBIAS.n45 VGND 0.00264f
C693 VBIAS.n46 VGND 0.02145f
C694 VBIAS.n47 VGND 0.00107f
C695 VBIAS.n48 VGND 0.00598f
C696 VBIAS.n49 VGND 0.00575f
C697 VBIAS.n50 VGND 0.00107f
C698 VBIAS.n51 VGND 0.02145f
C699 VBIAS.n52 VGND 0.00266f
C700 VBIAS.n53 VGND 0.00396f
C701 VBIAS.n54 VGND 0.04987f
C702 VBIAS.n55 VGND 0.00182f
C703 VBIAS.n56 VGND 0.00157f
C704 VBIAS.n57 VGND 0.00182f
C705 VBIAS.t19 VGND 0.0283f
C706 VBIAS.n58 VGND 0.00279f
C707 VBIAS.n59 VGND 0.00182f
C708 VBIAS.t18 VGND 0.0283f
C709 VBIAS.n60 VGND 0.00279f
C710 VBIAS.n61 VGND 0.00182f
C711 VBIAS.t12 VGND 0.0283f
C712 VBIAS.t1 VGND 0.00372f
C713 VBIAS.t13 VGND 0.00372f
C714 VBIAS.n62 VGND 0.00764f
C715 VBIAS.n63 VGND 0.00279f
C716 VBIAS.n64 VGND 0.00182f
C717 VBIAS.t0 VGND 0.0283f
C718 VBIAS.n65 VGND 0.00279f
C719 VBIAS.n66 VGND 0.00182f
C720 VBIAS.t14 VGND 0.0283f
C721 VBIAS.t11 VGND 0.00372f
C722 VBIAS.t15 VGND 0.00372f
C723 VBIAS.n67 VGND 0.00764f
C724 VBIAS.n68 VGND 0.00279f
C725 VBIAS.n69 VGND 0.00182f
C726 VBIAS.t10 VGND 0.0283f
C727 VBIAS.n70 VGND 0.00279f
C728 VBIAS.n71 VGND 0.00182f
C729 VBIAS.t17 VGND 0.0283f
C730 VBIAS.t16 VGND 0.04403f
C731 VBIAS.n72 VGND 0.02696f
C732 VBIAS.n73 VGND 0.00264f
C733 VBIAS.n74 VGND 0.02145f
C734 VBIAS.n75 VGND 0.00107f
C735 VBIAS.n76 VGND 0.00599f
C736 VBIAS.n77 VGND 0.00442f
C737 VBIAS.n78 VGND 0.00264f
C738 VBIAS.n79 VGND 0.02145f
C739 VBIAS.n80 VGND 0.00107f
C740 VBIAS.n81 VGND 0.00448f
C741 VBIAS.n82 VGND 0.01453f
C742 VBIAS.n83 VGND 0.0029f
C743 VBIAS.n84 VGND 0.00264f
C744 VBIAS.n85 VGND 0.02145f
C745 VBIAS.n86 VGND 0.00107f
C746 VBIAS.n87 VGND 0.00599f
C747 VBIAS.n88 VGND 0.00442f
C748 VBIAS.n89 VGND 0.00264f
C749 VBIAS.n90 VGND 0.02145f
C750 VBIAS.n91 VGND 0.00107f
C751 VBIAS.n92 VGND 0.00446f
C752 VBIAS.n93 VGND 0.01453f
C753 VBIAS.n94 VGND 0.00292f
C754 VBIAS.n95 VGND 0.00264f
C755 VBIAS.n96 VGND 0.02145f
C756 VBIAS.n97 VGND 0.00107f
C757 VBIAS.n98 VGND 0.00599f
C758 VBIAS.n99 VGND 0.00442f
C759 VBIAS.n100 VGND 0.00264f
C760 VBIAS.n101 VGND 0.02145f
C761 VBIAS.n102 VGND 0.00107f
C762 VBIAS.n103 VGND 0.00598f
C763 VBIAS.n104 VGND 0.00417f
C764 VBIAS.n105 VGND 0.00264f
C765 VBIAS.n106 VGND 0.02145f
C766 VBIAS.n107 VGND 0.00108f
C767 VBIAS.n108 VGND 0.00555f
C768 VBIAS.n109 VGND 0.01432f
C769 VBIAS.n110 VGND 0.0845f
