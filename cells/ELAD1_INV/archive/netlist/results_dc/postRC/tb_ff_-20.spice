* inverter postRC ff_-20
.lib /foss/pdks/sky130A/libs.tech/ngspice/sky130.lib.spice ff
.include /foss/designs/ELAD-1/cells/ELAD1_INV/pex_rc/ELAD1_INV_rc_sub.spice
XDUT A Y VDPWR VGND  ELAD1_INV
VG0 VGND 0 0
VDD VDPWR 0 1.8
VIN A 0 0
.option rshunt=1e12
.temp -20
.control
set filetype=ascii
dc VIN 0 1.8 0.005
wrdata results_dc/postRC/sweeps/vtc_ff_-20.txt v(Y)
wrdata results_dc/postRC/sweeps/idd_ff_-20.txt i(VDD)
quit
.endc
.end
