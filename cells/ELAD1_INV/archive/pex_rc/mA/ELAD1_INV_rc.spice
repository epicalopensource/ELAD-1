* SPICE3 file created from ELAD1_INV_flat.ext - technology: sky130A

X0 Y.t1 A.t1 VDPWR.t1 VDPWR.t0 sky130_fd_pr__pfet_01v8 ad=0.3 pd=2.6 as=0.3 ps=2.6 w=1 l=0.15
X1 Y.t0 A.t0 VGND.t1 VGND.t0 sky130_fd_pr__nfet_01v8 ad=0.195 pd=1.9 as=0.195 ps=1.9 w=0.65 l=0.15
C0 A VDPWR 0.29766f
C1 A Y 0.46178f
C2 Y VDPWR 0.21762f
R0 Y.n0 Y.t1 360.437
R1 Y.n0 Y.t0 228.969
R2 Y Y.n0 3.13978
R3 A.n0 A.t1 421.25
R4 A.n0 A.t0 365.252
R5 A A.n0 2.76252
R6 VDPWR.n25 VDPWR.n18 681.178
R7 VDPWR.n29 VDPWR.n15 681.178
R8 VDPWR.n40 VDPWR.n2 681.178
R9 VDPWR.n10 VDPWR.n6 681.178
R10 VDPWR.n0 VDPWR.t1 356.654
R11 VDPWR.n18 VDPWR.n17 254.119
R12 VDPWR.n21 VDPWR.n17 254.119
R13 VDPWR.n21 VDPWR.n4 254.119
R14 VDPWR.n40 VDPWR.n4 254.119
R15 VDPWR.n29 VDPWR.n20 254.119
R16 VDPWR.n33 VDPWR.n15 254.119
R17 VDPWR.n33 VDPWR.n7 254.119
R18 VDPWR.n37 VDPWR.n7 254.119
R19 VDPWR.n37 VDPWR.n6 254.119
R20 VDPWR.n8 VDPWR.n2 254.119
R21 VDPWR.n31 VDPWR.n30 185.232
R22 VDPWR.n39 VDPWR.n5 185.232
R23 VDPWR.n5 VDPWR.n2 185
R24 VDPWR.n42 VDPWR.n2 185
R25 VDPWR.n8 VDPWR.n1 185
R26 VDPWR.n12 VDPWR.n10 185
R27 VDPWR.n39 VDPWR.n6 185
R28 VDPWR.n13 VDPWR.n6 185
R29 VDPWR.n38 VDPWR.n37 185
R30 VDPWR.n37 VDPWR.n36 185
R31 VDPWR.n16 VDPWR.n7 185
R32 VDPWR.n35 VDPWR.n7 185
R33 VDPWR.n33 VDPWR.n32 185
R34 VDPWR.n34 VDPWR.n33 185
R35 VDPWR.n31 VDPWR.n15 185
R36 VDPWR.n15 VDPWR.n14 185
R37 VDPWR.n30 VDPWR.n29 185
R38 VDPWR.n29 VDPWR.n28 185
R39 VDPWR.n27 VDPWR.n20 185
R40 VDPWR.n26 VDPWR.n25 185
R41 VDPWR.n31 VDPWR.n18 185
R42 VDPWR.n24 VDPWR.n18 185
R43 VDPWR.n32 VDPWR.n17 185
R44 VDPWR.n23 VDPWR.n17 185
R45 VDPWR.n21 VDPWR.n16 185
R46 VDPWR.n22 VDPWR.n21 185
R47 VDPWR.n38 VDPWR.n4 185
R48 VDPWR.n4 VDPWR.n3 185
R49 VDPWR.n40 VDPWR.n39 185
R50 VDPWR.n41 VDPWR.n40 185
R51 VDPWR.n32 VDPWR.n31 132.047
R52 VDPWR.n32 VDPWR.n16 132.047
R53 VDPWR.n39 VDPWR.n38 132.047
R54 VDPWR.n9 VDPWR.n8 75.3262
R55 VDPWR.n20 VDPWR.n19 75.3262
R56 VDPWR.n25 VDPWR.n19 75.3262
R57 VDPWR.n10 VDPWR.n9 75.3262
R58 VDPWR.n13 VDPWR.n12 72.6593
R59 VDPWR.n28 VDPWR.n14 72.6593
R60 VDPWR.n26 VDPWR.n24 72.6593
R61 VDPWR.n42 VDPWR.n41 72.6593
R62 VDPWR.n38 VDPWR.t0 69.6916
R63 VDPWR.n16 VDPWR.t0 62.3557
R64 VDPWR.n9 VDPWR.n5 54.8384
R65 VDPWR.n30 VDPWR.n19 54.8384
R66 VDPWR.n42 VDPWR.n1 27.1064
R67 VDPWR.n34 VDPWR.n14 27.1064
R68 VDPWR.n35 VDPWR.n34 27.1064
R69 VDPWR.n36 VDPWR.n35 27.1064
R70 VDPWR.n36 VDPWR.n13 27.1064
R71 VDPWR.n27 VDPWR.n26 27.1064
R72 VDPWR.n28 VDPWR.n27 27.1064
R73 VDPWR.n24 VDPWR.n23 27.1064
R74 VDPWR.n23 VDPWR.n22 27.1064
R75 VDPWR.n22 VDPWR.n3 27.1064
R76 VDPWR.n41 VDPWR.n3 27.1064
R77 VDPWR.n43 VDPWR.n42 9.3005
R78 VDPWR.n12 VDPWR.n11 5.5376
R79 VDPWR.n11 VDPWR.n1 5.51094
R80 VDPWR.n11 VDPWR.n0 1.92873
R81 VDPWR VDPWR.n43 0.117375
R82 VDPWR.n43 VDPWR.n0 0.017375
R83 VGND.n24 VGND.n11 1124.06
R84 VGND.n35 VGND.n2 1124.06
R85 VGND.n31 VGND.n7 1124.06
R86 VGND.n15 VGND.n9 1124.06
R87 VGND.n24 VGND.n10 585
R88 VGND.n24 VGND.n23 585
R89 VGND.t0 VGND.n25 585
R90 VGND.n25 VGND.n1 585
R91 VGND.n5 VGND.n2 585
R92 VGND.n37 VGND.n2 585
R93 VGND.n36 VGND.n35 585
R94 VGND.n4 VGND.n3 585
R95 VGND.n29 VGND.n6 585
R96 VGND.n31 VGND.n30 585
R97 VGND.n7 VGND.n5 585
R98 VGND.n28 VGND.n7 585
R99 VGND.n26 VGND.t0 585
R100 VGND.n27 VGND.n26 585
R101 VGND.n10 VGND.n9 585
R102 VGND.n9 VGND.n8 585
R103 VGND.n15 VGND.n14 585
R104 VGND.n13 VGND.n12 585
R105 VGND.n20 VGND.n19 585
R106 VGND.n21 VGND.n11 585
R107 VGND.n33 VGND.n5 537.067
R108 VGND.n17 VGND.n10 537.067
R109 VGND.n19 VGND.n13 417.176
R110 VGND.n25 VGND.n2 417.176
R111 VGND.n25 VGND.n24 417.176
R112 VGND.n6 VGND.n4 417.176
R113 VGND.n26 VGND.n7 417.176
R114 VGND.n26 VGND.n9 417.176
R115 VGND.t0 VGND.n5 354.76
R116 VGND.t0 VGND.n10 354.76
R117 VGND.n0 VGND.t1 222.308
R118 VGND.n34 VGND.n33 215.619
R119 VGND.n33 VGND.n32 215.619
R120 VGND.n17 VGND.n16 215.619
R121 VGND.n18 VGND.n17 215.619
R122 VGND.n34 VGND.n4 153.763
R123 VGND.n32 VGND.n6 153.763
R124 VGND.n16 VGND.n13 153.763
R125 VGND.n18 VGND.n11 153.763
R126 VGND.n19 VGND.n18 153.763
R127 VGND.n16 VGND.n15 153.763
R128 VGND.n35 VGND.n34 153.763
R129 VGND.n32 VGND.n31 153.763
R130 VGND.n37 VGND.n36 73.0358
R131 VGND.n30 VGND.n28 73.0358
R132 VGND.n23 VGND.n21 73.0358
R133 VGND.n14 VGND.n8 73.0358
R134 VGND.n37 VGND.n1 27.1064
R135 VGND.n36 VGND.n3 27.1064
R136 VGND.n29 VGND.n3 27.1064
R137 VGND.n30 VGND.n29 27.1064
R138 VGND.n28 VGND.n27 27.1064
R139 VGND.n27 VGND.n8 27.1064
R140 VGND.n21 VGND.n20 27.1064
R141 VGND.n20 VGND.n12 27.1064
R142 VGND.n14 VGND.n12 27.1064
R143 VGND.n38 VGND.n37 9.3005
R144 VGND.n23 VGND.n22 5.5376
R145 VGND.n22 VGND.n1 5.51094
R146 VGND.n22 VGND.n0 1.92998
R147 VGND VGND.n38 0.118625
R148 VGND.n38 VGND.n0 0.016125
C3 Y VGND 0.66328f
C4 A VGND 0.67485f
C5 VDPWR VGND 1.54456f **FLOATING
C6 VDPWR.t1 VGND 0.00918f **FLOATING
C7 VDPWR.n0 VGND 0.07405f **FLOATING
C8 VDPWR.n1 VGND 0.00215f **FLOATING
C9 VDPWR.n2 VGND 0.00418f **FLOATING
C10 VDPWR.n3 VGND 0.00215f **FLOATING
C11 VDPWR.n4 VGND 0.00215f **FLOATING
C12 VDPWR.n5 VGND 0.0585f **FLOATING
C13 VDPWR.n6 VGND 0.00425f **FLOATING
C14 VDPWR.t0 VGND 0.01639f **FLOATING
C15 VDPWR.n7 VGND 0.00215f **FLOATING
C16 VDPWR.n8 VGND 0.00215f **FLOATING
C17 VDPWR.n10 VGND 0.00418f **FLOATING
C18 VDPWR.n11 VGND 0 **FLOATING
C19 VDPWR.n12 VGND 0.00437f **FLOATING
C20 VDPWR.n13 VGND 0.00425f **FLOATING
C21 VDPWR.n14 VGND 0.00425f **FLOATING
C22 VDPWR.n15 VGND 0.00425f **FLOATING
C23 VDPWR.n16 VGND 0.02413f **FLOATING
C24 VDPWR.n17 VGND 0.00215f **FLOATING
C25 VDPWR.n18 VGND 0.00425f **FLOATING
C26 VDPWR.n20 VGND 0.00215f **FLOATING
C27 VDPWR.n21 VGND 0.00215f **FLOATING
C28 VDPWR.n22 VGND 0.00215f **FLOATING
C29 VDPWR.n23 VGND 0.00215f **FLOATING
C30 VDPWR.n24 VGND 0.00425f **FLOATING
C31 VDPWR.n25 VGND 0.00418f **FLOATING
C32 VDPWR.n26 VGND 0.00418f **FLOATING
C33 VDPWR.n27 VGND 0.00215f **FLOATING
C34 VDPWR.n28 VGND 0.00418f **FLOATING
C35 VDPWR.n29 VGND 0.00418f **FLOATING
C36 VDPWR.n30 VGND 0.0585f **FLOATING
C37 VDPWR.n31 VGND 0.03938f **FLOATING
C38 VDPWR.n32 VGND 0.03278f **FLOATING
C39 VDPWR.n33 VGND 0.00215f **FLOATING
C40 VDPWR.n34 VGND 0.00215f **FLOATING
C41 VDPWR.n35 VGND 0.00215f **FLOATING
C42 VDPWR.n36 VGND 0.00215f **FLOATING
C43 VDPWR.n37 VGND 0.00215f **FLOATING
C44 VDPWR.n38 VGND 0.02504f **FLOATING
C45 VDPWR.n39 VGND 0.03938f **FLOATING
C46 VDPWR.n40 VGND 0.00425f **FLOATING
C47 VDPWR.n41 VGND 0.00425f **FLOATING
C48 VDPWR.n42 VGND 0.00418f **FLOATING
C49 VDPWR.n43 VGND 0.01881f **FLOATING
C50 A.t1 VGND 0.07722f **FLOATING
C51 A.t0 VGND 0.06471f **FLOATING
C52 A.n0 VGND 0.42465f **FLOATING
C53 Y.t1 VGND 0.07069f **FLOATING
C54 Y.t0 VGND 0.04888f **FLOATING
C55 Y.n0 VGND 0.41895f **FLOATING
