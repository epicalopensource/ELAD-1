* SPICE3 file created from ELAD1_VICTIM_BASELINE_flat.ext - technology: sky130A

X0 a_1213_1627# a_2915_1627# SUBQ.t1 sky130_fd_pr__res_xhigh_po_0p69 l=3.17
X1 a_1213_1921# a_2915_1627# SUBQ.t1 sky130_fd_pr__res_xhigh_po_0p69 l=3.17
X2 VGND.t4 VGND.t2 VGND.t3 SUBQ.t4 sky130_fd_pr__nfet_01v8 ad=0.5 pd=3 as=0 ps=0 w=1 l=1
X3 a_175_745# a_1213_745# SUBQ.t0 sky130_fd_pr__res_xhigh_po_0p69 l=3.17
X4 a_1213_1039# a_2915_1039# SUBQ.t1 sky130_fd_pr__res_xhigh_po_0p69 l=3.17
X5 VGND.t7 VGND.t5 VGND.t6 SUBQ.t5 sky130_fd_pr__nfet_01v8 ad=0.25 pd=1.5 as=0 ps=0 w=1 l=1
X6 a_1213_1333# a_2915_1039# SUBQ.t1 sky130_fd_pr__res_xhigh_po_0p69 l=3.17
X7 a_1213_745# OUT.t2 SUBQ.t1 sky130_fd_pr__res_xhigh_po_0p69 l=3.17
X8 a_175_1333# a_1213_1627# SUBQ.t0 sky130_fd_pr__res_xhigh_po_0p69 l=3.17
X9 VDPWR.t0 a_1213_1921# SUBQ.t0 sky130_fd_pr__res_xhigh_po_0p69 l=3.17
X10 a_175_745# a_1213_1039# SUBQ.t0 sky130_fd_pr__res_xhigh_po_0p69 l=3.17
X11 a_175_1333# a_1213_1333# SUBQ.t0 sky130_fd_pr__res_xhigh_po_0p69 l=3.17
X12 OUT.t0 VQUIET.t1 VGND.t1 SUBQ.t2 sky130_fd_pr__nfet_01v8 ad=0.25 pd=1.5 as=0.5 ps=3 w=1 l=1
X13 VGND.t10 VGND.t8 VGND.t9 SUBQ.t6 sky130_fd_pr__nfet_01v8 ad=0.5 pd=3 as=0 ps=0 w=1 l=1
X14 VGND.t0 VQUIET.t0 OUT.t1 SUBQ.t3 sky130_fd_pr__nfet_01v8 ad=0.5 pd=3 as=0.25 ps=1.5 w=1 l=1
X15 VGND.t13 VGND.t11 VGND.t12 SUBQ.t7 sky130_fd_pr__nfet_01v8 ad=0.25 pd=1.5 as=0 ps=0 w=1 l=1
C0 VQUIET a_175_745# 0.01132f
C1 VDPWR a_175_1333# 0.19678f
C2 a_2915_1039# a_1213_1333# 0.00906f
C3 OUT a_1213_1039# 0.01663f
C4 VGND VQUIET 0.47249f
C5 a_1213_1333# a_175_1333# 0.00935f
C6 VQUIET a_1213_1627# 0.0031f
C7 VGND a_175_745# 0.00573f
C8 VDPWR a_1213_1039# 0.00757f
C9 VQUIET OUT 0.28451f
C10 VQUIET a_1213_1921# 0.00202f
C11 a_1213_1039# a_1213_745# 0.23399f
C12 a_1213_1039# a_1213_1333# 0.23375f
C13 a_1213_1039# a_2915_1039# 0.00907f
C14 VDPWR VQUIET 0.02772f
C15 VGND a_1213_1627# 0
C16 VQUIET a_1213_745# 0.03044f
C17 VQUIET a_1213_1333# 0.00531f
C18 VGND OUT 0.25578f
C19 VDPWR a_175_745# 0.00547f
C20 VGND a_1213_1921# 0
C21 a_175_745# a_1213_745# 0.00936f
C22 OUT a_1213_1627# 0.00413f
C23 a_1213_1627# a_2915_1627# 0.00906f
C24 a_1213_1627# a_1213_1921# 0.23385f
C25 VQUIET a_175_1333# 0.00163f
C26 VGND VDPWR 0
C27 OUT a_2915_1627# 0.00387f
C28 OUT a_1213_1921# 0.00259f
C29 a_1213_1921# a_2915_1627# 0.00906f
C30 VGND a_1213_745# 0.00305f
C31 a_175_745# a_175_1333# 0.15802f
C32 VGND a_1213_1333# 0
C33 VDPWR a_1213_1627# 0.03253f
C34 VDPWR OUT 0.0475f
C35 VDPWR a_2915_1627# 0.18056f
C36 VDPWR a_1213_1921# 0.13898f
C37 VQUIET a_1213_1039# 0.01085f
C38 a_1213_1333# a_1213_1627# 0.23385f
C39 OUT a_1213_745# 0.0675f
C40 VGND a_175_1333# 0
C41 OUT a_1213_1333# 0.00749f
C42 OUT a_2915_1039# 0.1696f
C43 a_2915_1039# a_2915_1627# 0.15416f
C44 a_175_745# a_1213_1039# 0.00935f
C45 a_1213_1627# a_175_1333# 0.00935f
C46 VDPWR a_1213_745# 0.00465f
C47 VDPWR a_1213_1333# 0.01421f
C48 VDPWR a_2915_1039# 0.00815f
C49 VGND a_1213_1039# 0.00107f
R0 VQUIET.n4 VQUIET.n3 184.74
R1 VQUIET.n15 VQUIET.n14 184.74
R2 VQUIET.n5 VQUIET.n4 77.1778
R3 VQUIET.n14 VQUIET.n13 77.1778
R4 VQUIET.n3 VQUIET.n2 27.1064
R5 VQUIET.n15 VQUIET.n11 27.1064
R6 VQUIET.n4 VQUIET.t0 24.1005
R7 VQUIET.n14 VQUIET.t1 24.1005
R8 VQUIET.n6 VQUIET.n5 23.1414
R9 VQUIET.n13 VQUIET.n12 23.1396
R10 VQUIET.n5 VQUIET.n2 11.3247
R11 VQUIET.n13 VQUIET.n11 11.3247
R12 VQUIET.n16 VQUIET.n15 9.37626
R13 VQUIET.n3 VQUIET.n0 9.37436
R14 VQUIET.n2 VQUIET.n1 9.3005
R15 VQUIET.n11 VQUIET.n10 9.3005
R16 VQUIET.n7 VQUIET.n0 4.56105
R17 VQUIET.n7 VQUIET.n6 4.56007
R18 VQUIET.n17 VQUIET.n16 4.5005
R19 VQUIET.n12 VQUIET.n9 4.5005
R20 VQUIET.n18 VQUIET.n17 3.42565
R21 VQUIET.n9 VQUIET.n8 3.42565
R22 VQUIET.n8 VQUIET.n7 1.8553
R23 VQUIET VQUIET.n18 0.734697
R24 VQUIET.n17 VQUIET.n9 0.121712
R25 VQUIET.n1 VQUIET.n0 0.063
R26 VQUIET.n16 VQUIET.n10 0.0611061
R27 VQUIET.n12 VQUIET.n10 0.0611061
R28 VQUIET.n6 VQUIET.n1 0.0592121
R29 VQUIET.n18 VQUIET.n8 0.0574697
R30 VGND.n3 VGND.t12 131.55
R31 VGND.n12 VGND.t4 131.48
R32 VGND.n7 VGND.t6 131.48
R33 VGND.n6 VGND.t1 131.48
R34 VGND.n5 VGND.t0 131.48
R35 VGND.n4 VGND.t10 131.48
R36 VGND.n2 VGND.n1 97.1573
R37 VGND.n10 VGND.n9 97.1573
R38 VGND.n0 VGND.t8 84.9927
R39 VGND.n0 VGND.t11 84.9916
R40 VGND.n8 VGND.t5 84.9916
R41 VGND.n8 VGND.t2 84.9916
R42 VGND.n1 VGND.t9 30.0005
R43 VGND.n1 VGND.t13 30.0005
R44 VGND.n9 VGND.t3 30.0005
R45 VGND.n9 VGND.t7 30.0005
R46 VGND.n11 VGND.n10 4.32314
R47 VGND.n3 VGND.n2 4.32314
R48 VGND.n2 VGND.n0 0.311823
R49 VGND.n10 VGND.n8 0.311823
R50 VGND.n6 VGND.n5 0.141735
R51 VGND.n12 VGND.n11 0.071235
R52 VGND.n4 VGND.n3 0.071235
R53 VGND.n11 VGND.n7 0.071
R54 VGND.n7 VGND.n6 0.057605
R55 VGND.n5 VGND.n4 0.057605
R56 VGND VGND.n12 0.01789
R57 OUT.n1 OUT.n0 102.615
R58 OUT.n1 OUT.t2 72.887
R59 OUT.n0 OUT.t1 30.0005
R60 OUT.n0 OUT.t0 30.0005
R61 OUT OUT.n1 0.244619
R62 VDPWR VDPWR.t0 72.9142
R63 SUBQ.n473 SUBQ.n3 715.197
R64 SUBQ.n423 SUBQ.n422 715.197
R65 SUBQ.n205 SUBQ.n163 710.913
R66 SUBQ.n168 SUBQ.n165 710.913
R67 SUBQ.n310 SUBQ.n108 594.604
R68 SUBQ.n360 SUBQ.n69 592.391
R69 SUBQ.n262 SUBQ.n145 590.138
R70 SUBQ.n423 SUBQ.n6 585
R71 SUBQ.n424 SUBQ.n423 585
R72 SUBQ.n421 SUBQ.n420 585
R73 SUBQ.n421 SUBQ.n26 585
R74 SUBQ.n28 SUBQ.n27 585
R75 SUBQ.n405 SUBQ.n27 585
R76 SUBQ.n37 SUBQ.n35 585
R77 SUBQ.n39 SUBQ.n37 585
R78 SUBQ.n411 SUBQ.n410 585
R79 SUBQ.n410 SUBQ.n409 585
R80 SUBQ.n36 SUBQ.n34 585
R81 SUBQ.n38 SUBQ.n36 585
R82 SUBQ.n401 SUBQ.n400 585
R83 SUBQ.n402 SUBQ.n401 585
R84 SUBQ.n43 SUBQ.n42 585
R85 SUBQ.n42 SUBQ.n41 585
R86 SUBQ.n392 SUBQ.n391 585
R87 SUBQ.n391 SUBQ.n390 585
R88 SUBQ.n383 SUBQ.n49 585
R89 SUBQ.n50 SUBQ.n49 585
R90 SUBQ.n385 SUBQ.n384 585
R91 SUBQ.n386 SUBQ.n385 585
R92 SUBQ.n54 SUBQ.n53 585
R93 SUBQ.n53 SUBQ.n52 585
R94 SUBQ.n375 SUBQ.n374 585
R95 SUBQ.n374 SUBQ.n373 585
R96 SUBQ.n366 SUBQ.n60 585
R97 SUBQ.n61 SUBQ.n60 585
R98 SUBQ.n368 SUBQ.n367 585
R99 SUBQ.n369 SUBQ.n368 585
R100 SUBQ.n65 SUBQ.n64 585
R101 SUBQ.n64 SUBQ.n63 585
R102 SUBQ.n78 SUBQ.n76 585
R103 SUBQ.n80 SUBQ.n78 585
R104 SUBQ.n355 SUBQ.n354 585
R105 SUBQ.n354 SUBQ.n353 585
R106 SUBQ.n77 SUBQ.n75 585
R107 SUBQ.n79 SUBQ.n77 585
R108 SUBQ.n347 SUBQ.n346 585
R109 SUBQ.n348 SUBQ.n347 585
R110 SUBQ.n90 SUBQ.n83 585
R111 SUBQ.n83 SUBQ.n82 585
R112 SUBQ.n338 SUBQ.n337 585
R113 SUBQ.n337 SUBQ.n336 585
R114 SUBQ.n91 SUBQ.n89 585
R115 SUBQ.n92 SUBQ.n91 585
R116 SUBQ.n331 SUBQ.n330 585
R117 SUBQ.n332 SUBQ.n331 585
R118 SUBQ.n96 SUBQ.n95 585
R119 SUBQ.n95 SUBQ.n94 585
R120 SUBQ.n322 SUBQ.n321 585
R121 SUBQ.n321 SUBQ.n320 585
R122 SUBQ.n103 SUBQ.n102 585
R123 SUBQ.n104 SUBQ.n103 585
R124 SUBQ.n315 SUBQ.n314 585
R125 SUBQ.n316 SUBQ.n315 585
R126 SUBQ.n115 SUBQ.n107 585
R127 SUBQ.n107 SUBQ.n106 585
R128 SUBQ.n305 SUBQ.n304 585
R129 SUBQ.n304 SUBQ.n303 585
R130 SUBQ.n116 SUBQ.n114 585
R131 SUBQ.n117 SUBQ.n116 585
R132 SUBQ.n298 SUBQ.n297 585
R133 SUBQ.n299 SUBQ.n298 585
R134 SUBQ.n127 SUBQ.n120 585
R135 SUBQ.n120 SUBQ.n119 585
R136 SUBQ.n289 SUBQ.n288 585
R137 SUBQ.n288 SUBQ.n287 585
R138 SUBQ.n128 SUBQ.n126 585
R139 SUBQ.n129 SUBQ.n128 585
R140 SUBQ.n282 SUBQ.n281 585
R141 SUBQ.n283 SUBQ.n282 585
R142 SUBQ.n139 SUBQ.n132 585
R143 SUBQ.n132 SUBQ.n131 585
R144 SUBQ.n273 SUBQ.n272 585
R145 SUBQ.n272 SUBQ.n271 585
R146 SUBQ.n140 SUBQ.n138 585
R147 SUBQ.n141 SUBQ.n140 585
R148 SUBQ.n266 SUBQ.n265 585
R149 SUBQ.n267 SUBQ.n266 585
R150 SUBQ.n152 SUBQ.n144 585
R151 SUBQ.n144 SUBQ.n143 585
R152 SUBQ.n257 SUBQ.n256 585
R153 SUBQ.n256 SUBQ.n255 585
R154 SUBQ.n153 SUBQ.n151 585
R155 SUBQ.n154 SUBQ.n153 585
R156 SUBQ.n250 SUBQ.n249 585
R157 SUBQ.n251 SUBQ.n250 585
R158 SUBQ.n158 SUBQ.n157 585
R159 SUBQ.n157 SUBQ.n156 585
R160 SUBQ.n241 SUBQ.n240 585
R161 SUBQ.n240 SUBQ.n239 585
R162 SUBQ.n165 SUBQ.n164 585
R163 SUBQ.n166 SUBQ.n165 585
R164 SUBQ.n164 SUBQ.n163 585
R165 SUBQ.n163 SUBQ.n162 585
R166 SUBQ.n242 SUBQ.n241 585
R167 SUBQ.n243 SUBQ.n242 585
R168 SUBQ.n159 SUBQ.n158 585
R169 SUBQ.n160 SUBQ.n159 585
R170 SUBQ.n249 SUBQ.n248 585
R171 SUBQ.n248 SUBQ.n247 585
R172 SUBQ.n151 SUBQ.n150 585
R173 SUBQ.n150 SUBQ.n149 585
R174 SUBQ.n258 SUBQ.n257 585
R175 SUBQ.n259 SUBQ.n258 585
R176 SUBQ.n152 SUBQ.n146 585
R177 SUBQ.n147 SUBQ.n146 585
R178 SUBQ.n265 SUBQ.n264 585
R179 SUBQ.n264 SUBQ.n263 585
R180 SUBQ.n138 SUBQ.n137 585
R181 SUBQ.n137 SUBQ.n136 585
R182 SUBQ.n274 SUBQ.n273 585
R183 SUBQ.n275 SUBQ.n274 585
R184 SUBQ.n139 SUBQ.n133 585
R185 SUBQ.n134 SUBQ.n133 585
R186 SUBQ.n281 SUBQ.n280 585
R187 SUBQ.n280 SUBQ.n279 585
R188 SUBQ.n126 SUBQ.n125 585
R189 SUBQ.n125 SUBQ.n124 585
R190 SUBQ.n290 SUBQ.n289 585
R191 SUBQ.n291 SUBQ.n290 585
R192 SUBQ.n127 SUBQ.n121 585
R193 SUBQ.n122 SUBQ.n121 585
R194 SUBQ.n297 SUBQ.n296 585
R195 SUBQ.n296 SUBQ.n295 585
R196 SUBQ.n114 SUBQ.n113 585
R197 SUBQ.n113 SUBQ.n112 585
R198 SUBQ.n306 SUBQ.n305 585
R199 SUBQ.n307 SUBQ.n306 585
R200 SUBQ.n115 SUBQ.n109 585
R201 SUBQ.n110 SUBQ.n109 585
R202 SUBQ.n314 SUBQ.n313 585
R203 SUBQ.n313 SUBQ.n312 585
R204 SUBQ.n102 SUBQ.n101 585
R205 SUBQ.n101 SUBQ.n100 585
R206 SUBQ.n323 SUBQ.n322 585
R207 SUBQ.n324 SUBQ.n323 585
R208 SUBQ.n97 SUBQ.n96 585
R209 SUBQ.n98 SUBQ.n97 585
R210 SUBQ.n330 SUBQ.n329 585
R211 SUBQ.n329 SUBQ.n328 585
R212 SUBQ.n89 SUBQ.n88 585
R213 SUBQ.n88 SUBQ.n87 585
R214 SUBQ.n339 SUBQ.n338 585
R215 SUBQ.n340 SUBQ.n339 585
R216 SUBQ.n90 SUBQ.n84 585
R217 SUBQ.n85 SUBQ.n84 585
R218 SUBQ.n346 SUBQ.n345 585
R219 SUBQ.n345 SUBQ.n344 585
R220 SUBQ.n75 SUBQ.n73 585
R221 SUBQ.n73 SUBQ.n71 585
R222 SUBQ.n356 SUBQ.n355 585
R223 SUBQ.n357 SUBQ.n356 585
R224 SUBQ.n76 SUBQ.n74 585
R225 SUBQ.n74 SUBQ.n72 585
R226 SUBQ.n66 SUBQ.n65 585
R227 SUBQ.n67 SUBQ.n66 585
R228 SUBQ.n367 SUBQ.n365 585
R229 SUBQ.n365 SUBQ.n364 585
R230 SUBQ.n366 SUBQ.n59 585
R231 SUBQ.n59 SUBQ.n58 585
R232 SUBQ.n376 SUBQ.n375 585
R233 SUBQ.n377 SUBQ.n376 585
R234 SUBQ.n55 SUBQ.n54 585
R235 SUBQ.n56 SUBQ.n55 585
R236 SUBQ.n384 SUBQ.n382 585
R237 SUBQ.n382 SUBQ.n381 585
R238 SUBQ.n383 SUBQ.n48 585
R239 SUBQ.n48 SUBQ.n47 585
R240 SUBQ.n393 SUBQ.n392 585
R241 SUBQ.n394 SUBQ.n393 585
R242 SUBQ.n44 SUBQ.n43 585
R243 SUBQ.n45 SUBQ.n44 585
R244 SUBQ.n400 SUBQ.n399 585
R245 SUBQ.n399 SUBQ.n398 585
R246 SUBQ.n34 SUBQ.n33 585
R247 SUBQ.n33 SUBQ.n32 585
R248 SUBQ.n412 SUBQ.n411 585
R249 SUBQ.n413 SUBQ.n412 585
R250 SUBQ.n35 SUBQ.n29 585
R251 SUBQ.n30 SUBQ.n29 585
R252 SUBQ.n418 SUBQ.n28 585
R253 SUBQ.n418 SUBQ.n417 585
R254 SUBQ.n420 SUBQ.n419 585
R255 SUBQ.n419 SUBQ.n2 585
R256 SUBQ.n6 SUBQ.n3 585
R257 SUBQ.n475 SUBQ.n3 585
R258 SUBQ.n422 SUBQ.n24 585
R259 SUBQ.n429 SUBQ.n428 585
R260 SUBQ.n431 SUBQ.n430 585
R261 SUBQ.n434 SUBQ.n433 585
R262 SUBQ.n432 SUBQ.n22 585
R263 SUBQ.n439 SUBQ.n438 585
R264 SUBQ.n441 SUBQ.n440 585
R265 SUBQ.n444 SUBQ.n443 585
R266 SUBQ.n442 SUBQ.n20 585
R267 SUBQ.n449 SUBQ.n448 585
R268 SUBQ.n451 SUBQ.n450 585
R269 SUBQ.n454 SUBQ.n453 585
R270 SUBQ.n452 SUBQ.n18 585
R271 SUBQ.n459 SUBQ.n458 585
R272 SUBQ.n461 SUBQ.n460 585
R273 SUBQ.n463 SUBQ.n462 585
R274 SUBQ.n16 SUBQ.n15 585
R275 SUBQ.n469 SUBQ.n468 585
R276 SUBQ.n5 SUBQ.n4 585
R277 SUBQ.n474 SUBQ.n473 585
R278 SUBQ.n206 SUBQ.n205 585
R279 SUBQ.n209 SUBQ.n190 585
R280 SUBQ.n210 SUBQ.n189 585
R281 SUBQ.n211 SUBQ.n188 585
R282 SUBQ.n196 SUBQ.n186 585
R283 SUBQ.n215 SUBQ.n185 585
R284 SUBQ.n216 SUBQ.n184 585
R285 SUBQ.n217 SUBQ.n183 585
R286 SUBQ.n203 SUBQ.n193 585
R287 SUBQ.n193 SUBQ.n181 585
R288 SUBQ.n221 SUBQ.n180 585
R289 SUBQ.n222 SUBQ.n179 585
R290 SUBQ.n223 SUBQ.n178 585
R291 SUBQ.n199 SUBQ.n176 585
R292 SUBQ.n227 SUBQ.n175 585
R293 SUBQ.n228 SUBQ.n174 585
R294 SUBQ.n203 SUBQ.n173 585
R295 SUBQ.n229 SUBQ.n173 585
R296 SUBQ.n191 SUBQ.n171 585
R297 SUBQ.n233 SUBQ.n170 585
R298 SUBQ.n234 SUBQ.n169 585
R299 SUBQ.n235 SUBQ.n168 585
R300 SUBQ.n190 SUBQ.n189 308.349
R301 SUBQ.n196 SUBQ.n188 308.349
R302 SUBQ.n185 SUBQ.n184 308.349
R303 SUBQ.n193 SUBQ.n183 308.349
R304 SUBQ.n193 SUBQ.n180 308.349
R305 SUBQ.n179 SUBQ.n178 308.349
R306 SUBQ.n199 SUBQ.n175 308.349
R307 SUBQ.n174 SUBQ.n173 308.349
R308 SUBQ.n191 SUBQ.n173 308.349
R309 SUBQ.n170 SUBQ.n169 308.349
R310 SUBQ.n419 SUBQ.n3 308.349
R311 SUBQ.n419 SUBQ.n418 308.349
R312 SUBQ.n418 SUBQ.n29 308.349
R313 SUBQ.n412 SUBQ.n29 308.349
R314 SUBQ.n412 SUBQ.n33 308.349
R315 SUBQ.n399 SUBQ.n33 308.349
R316 SUBQ.n399 SUBQ.n44 308.349
R317 SUBQ.n393 SUBQ.n44 308.349
R318 SUBQ.n393 SUBQ.n48 308.349
R319 SUBQ.n382 SUBQ.n48 308.349
R320 SUBQ.n382 SUBQ.n55 308.349
R321 SUBQ.n376 SUBQ.n55 308.349
R322 SUBQ.n376 SUBQ.n59 308.349
R323 SUBQ.n365 SUBQ.n59 308.349
R324 SUBQ.n365 SUBQ.n66 308.349
R325 SUBQ.n74 SUBQ.n66 308.349
R326 SUBQ.n356 SUBQ.n74 308.349
R327 SUBQ.n356 SUBQ.n73 308.349
R328 SUBQ.n345 SUBQ.n73 308.349
R329 SUBQ.n345 SUBQ.n84 308.349
R330 SUBQ.n339 SUBQ.n84 308.349
R331 SUBQ.n339 SUBQ.n88 308.349
R332 SUBQ.n329 SUBQ.n88 308.349
R333 SUBQ.n329 SUBQ.n97 308.349
R334 SUBQ.n323 SUBQ.n97 308.349
R335 SUBQ.n323 SUBQ.n101 308.349
R336 SUBQ.n313 SUBQ.n101 308.349
R337 SUBQ.n313 SUBQ.n109 308.349
R338 SUBQ.n306 SUBQ.n109 308.349
R339 SUBQ.n306 SUBQ.n113 308.349
R340 SUBQ.n296 SUBQ.n113 308.349
R341 SUBQ.n296 SUBQ.n121 308.349
R342 SUBQ.n290 SUBQ.n121 308.349
R343 SUBQ.n290 SUBQ.n125 308.349
R344 SUBQ.n280 SUBQ.n125 308.349
R345 SUBQ.n280 SUBQ.n133 308.349
R346 SUBQ.n274 SUBQ.n133 308.349
R347 SUBQ.n274 SUBQ.n137 308.349
R348 SUBQ.n264 SUBQ.n137 308.349
R349 SUBQ.n264 SUBQ.n146 308.349
R350 SUBQ.n258 SUBQ.n146 308.349
R351 SUBQ.n258 SUBQ.n150 308.349
R352 SUBQ.n248 SUBQ.n150 308.349
R353 SUBQ.n248 SUBQ.n159 308.349
R354 SUBQ.n242 SUBQ.n159 308.349
R355 SUBQ.n242 SUBQ.n163 308.349
R356 SUBQ.n469 SUBQ.n5 308.349
R357 SUBQ.n462 SUBQ.n15 308.349
R358 SUBQ.n460 SUBQ.n459 308.349
R359 SUBQ.n453 SUBQ.n452 308.349
R360 SUBQ.n450 SUBQ.n449 308.349
R361 SUBQ.n443 SUBQ.n442 308.349
R362 SUBQ.n440 SUBQ.n439 308.349
R363 SUBQ.n433 SUBQ.n432 308.349
R364 SUBQ.n430 SUBQ.n429 308.349
R365 SUBQ.n423 SUBQ.n421 308.349
R366 SUBQ.n421 SUBQ.n27 308.349
R367 SUBQ.n37 SUBQ.n27 308.349
R368 SUBQ.n410 SUBQ.n37 308.349
R369 SUBQ.n410 SUBQ.n36 308.349
R370 SUBQ.n401 SUBQ.n36 308.349
R371 SUBQ.n401 SUBQ.n42 308.349
R372 SUBQ.n391 SUBQ.n42 308.349
R373 SUBQ.n391 SUBQ.n49 308.349
R374 SUBQ.n385 SUBQ.n49 308.349
R375 SUBQ.n385 SUBQ.n53 308.349
R376 SUBQ.n374 SUBQ.n53 308.349
R377 SUBQ.n374 SUBQ.n60 308.349
R378 SUBQ.n368 SUBQ.n60 308.349
R379 SUBQ.n368 SUBQ.n64 308.349
R380 SUBQ.n78 SUBQ.n64 308.349
R381 SUBQ.n354 SUBQ.n78 308.349
R382 SUBQ.n354 SUBQ.n77 308.349
R383 SUBQ.n347 SUBQ.n77 308.349
R384 SUBQ.n347 SUBQ.n83 308.349
R385 SUBQ.n337 SUBQ.n83 308.349
R386 SUBQ.n337 SUBQ.n91 308.349
R387 SUBQ.n331 SUBQ.n91 308.349
R388 SUBQ.n331 SUBQ.n95 308.349
R389 SUBQ.n321 SUBQ.n95 308.349
R390 SUBQ.n321 SUBQ.n103 308.349
R391 SUBQ.n315 SUBQ.n103 308.349
R392 SUBQ.n315 SUBQ.n107 308.349
R393 SUBQ.n304 SUBQ.n107 308.349
R394 SUBQ.n304 SUBQ.n116 308.349
R395 SUBQ.n298 SUBQ.n116 308.349
R396 SUBQ.n298 SUBQ.n120 308.349
R397 SUBQ.n288 SUBQ.n120 308.349
R398 SUBQ.n288 SUBQ.n128 308.349
R399 SUBQ.n282 SUBQ.n128 308.349
R400 SUBQ.n282 SUBQ.n132 308.349
R401 SUBQ.n272 SUBQ.n132 308.349
R402 SUBQ.n272 SUBQ.n140 308.349
R403 SUBQ.n266 SUBQ.n140 308.349
R404 SUBQ.n266 SUBQ.n144 308.349
R405 SUBQ.n256 SUBQ.n144 308.349
R406 SUBQ.n256 SUBQ.n153 308.349
R407 SUBQ.n250 SUBQ.n153 308.349
R408 SUBQ.n250 SUBQ.n157 308.349
R409 SUBQ.n240 SUBQ.n157 308.349
R410 SUBQ.n240 SUBQ.n165 308.349
R411 SUBQ.n471 SUBQ.n7 231.493
R412 SUBQ.n471 SUBQ.n8 231.493
R413 SUBQ.n471 SUBQ.n9 231.493
R414 SUBQ.n471 SUBQ.n10 231.493
R415 SUBQ.n471 SUBQ.n11 231.493
R416 SUBQ.n471 SUBQ.n12 231.493
R417 SUBQ.n471 SUBQ.n13 231.493
R418 SUBQ.n471 SUBQ.n14 231.493
R419 SUBQ.n471 SUBQ.n470 231.493
R420 SUBQ.n472 SUBQ.n471 231.493
R421 SUBQ.n204 SUBQ.n203 231.493
R422 SUBQ.n203 SUBQ.n195 231.493
R423 SUBQ.n203 SUBQ.n197 231.493
R424 SUBQ.n203 SUBQ.n194 231.493
R425 SUBQ.n203 SUBQ.n198 231.493
R426 SUBQ.n203 SUBQ.n200 231.493
R427 SUBQ.n203 SUBQ.n201 231.493
R428 SUBQ.n203 SUBQ.n192 231.493
R429 SUBQ.n203 SUBQ.n202 231.493
R430 SUBQ.n420 SUBQ.n6 139.315
R431 SUBQ.n420 SUBQ.n28 139.315
R432 SUBQ.n35 SUBQ.n28 139.315
R433 SUBQ.n411 SUBQ.n35 139.315
R434 SUBQ.n411 SUBQ.n34 139.315
R435 SUBQ.n400 SUBQ.n34 139.315
R436 SUBQ.n400 SUBQ.n43 139.315
R437 SUBQ.n392 SUBQ.n43 139.315
R438 SUBQ.n384 SUBQ.n383 139.315
R439 SUBQ.n384 SUBQ.n54 139.315
R440 SUBQ.n367 SUBQ.n366 139.315
R441 SUBQ.n367 SUBQ.n65 139.315
R442 SUBQ.n355 SUBQ.n76 139.315
R443 SUBQ.n355 SUBQ.n75 139.315
R444 SUBQ.n346 SUBQ.n75 139.315
R445 SUBQ.n338 SUBQ.n90 139.315
R446 SUBQ.n338 SUBQ.n89 139.315
R447 SUBQ.n330 SUBQ.n89 139.315
R448 SUBQ.n330 SUBQ.n96 139.315
R449 SUBQ.n322 SUBQ.n102 139.315
R450 SUBQ.n314 SUBQ.n102 139.315
R451 SUBQ.n305 SUBQ.n115 139.315
R452 SUBQ.n305 SUBQ.n114 139.315
R453 SUBQ.n297 SUBQ.n114 139.315
R454 SUBQ.n289 SUBQ.n127 139.315
R455 SUBQ.n289 SUBQ.n126 139.315
R456 SUBQ.n273 SUBQ.n139 139.315
R457 SUBQ.n273 SUBQ.n138 139.315
R458 SUBQ.n265 SUBQ.n138 139.315
R459 SUBQ.n257 SUBQ.n152 139.315
R460 SUBQ.n257 SUBQ.n151 139.315
R461 SUBQ.n249 SUBQ.n151 139.315
R462 SUBQ.n249 SUBQ.n158 139.315
R463 SUBQ.n241 SUBQ.n158 139.315
R464 SUBQ.n241 SUBQ.n164 139.315
R465 SUBQ.n346 SUBQ.t2 127.704
R466 SUBQ.n322 SUBQ.t3 127.704
R467 SUBQ.n422 SUBQ.n7 122.017
R468 SUBQ.n430 SUBQ.n8 122.017
R469 SUBQ.n432 SUBQ.n9 122.017
R470 SUBQ.n440 SUBQ.n10 122.017
R471 SUBQ.n442 SUBQ.n11 122.017
R472 SUBQ.n450 SUBQ.n12 122.017
R473 SUBQ.n452 SUBQ.n13 122.017
R474 SUBQ.n460 SUBQ.n14 122.017
R475 SUBQ.n470 SUBQ.n15 122.017
R476 SUBQ.n472 SUBQ.n5 122.017
R477 SUBQ.n205 SUBQ.n204 122.017
R478 SUBQ.n195 SUBQ.n188 122.017
R479 SUBQ.n197 SUBQ.n196 122.017
R480 SUBQ.n194 SUBQ.n183 122.017
R481 SUBQ.n198 SUBQ.n179 122.017
R482 SUBQ.n200 SUBQ.n199 122.017
R483 SUBQ.n201 SUBQ.n174 122.017
R484 SUBQ.n192 SUBQ.n170 122.017
R485 SUBQ.n202 SUBQ.n169 122.017
R486 SUBQ.n204 SUBQ.n190 122.017
R487 SUBQ.n195 SUBQ.n189 122.017
R488 SUBQ.n197 SUBQ.n185 122.017
R489 SUBQ.n194 SUBQ.n184 122.017
R490 SUBQ.n198 SUBQ.n180 122.017
R491 SUBQ.n200 SUBQ.n178 122.017
R492 SUBQ.n201 SUBQ.n175 122.017
R493 SUBQ.n192 SUBQ.n191 122.017
R494 SUBQ.n202 SUBQ.n168 122.017
R495 SUBQ.n473 SUBQ.n472 122.017
R496 SUBQ.n470 SUBQ.n469 122.017
R497 SUBQ.n462 SUBQ.n14 122.017
R498 SUBQ.n459 SUBQ.n13 122.017
R499 SUBQ.n453 SUBQ.n12 122.017
R500 SUBQ.n449 SUBQ.n11 122.017
R501 SUBQ.n443 SUBQ.n10 122.017
R502 SUBQ.n439 SUBQ.n9 122.017
R503 SUBQ.n433 SUBQ.n8 122.017
R504 SUBQ.n429 SUBQ.n7 122.017
R505 SUBQ.n471 SUBQ.n6 118.031
R506 SUBQ.n375 SUBQ.t0 118.031
R507 SUBQ.n203 SUBQ.n164 116.096
R508 SUBQ.n383 SUBQ.t4 112.225
R509 SUBQ.n281 SUBQ.t7 112.225
R510 SUBQ.t1 SUBQ.n126 110.29
R511 SUBQ.n152 SUBQ.n145 110.29
R512 SUBQ.n69 SUBQ.n65 106.421
R513 SUBQ.n366 SUBQ.t5 89.0067
R514 SUBQ.n297 SUBQ.t6 89.0067
R515 SUBQ.n115 SUBQ.n108 71.5924
R516 SUBQ.n314 SUBQ.n108 67.7226
R517 SUBQ.n375 SUBQ.t5 50.3083
R518 SUBQ.n127 SUBQ.t6 50.3083
R519 SUBQ.n475 SUBQ.n474 46.4701
R520 SUBQ.n424 SUBQ.n24 46.4701
R521 SUBQ.n206 SUBQ.n162 46.1918
R522 SUBQ.n235 SUBQ.n166 46.1918
R523 SUBQ.n76 SUBQ.n69 32.8941
R524 SUBQ.n281 SUBQ.t1 29.0242
R525 SUBQ.n265 SUBQ.n145 29.0242
R526 SUBQ.n392 SUBQ.t4 27.0893
R527 SUBQ.n139 SUBQ.t7 27.0893
R528 SUBQ.t0 SUBQ.n54 21.2846
R529 SUBQ.n475 SUBQ.n2 20.0353
R530 SUBQ.n417 SUBQ.n2 20.0353
R531 SUBQ.n417 SUBQ.n30 20.0353
R532 SUBQ.n413 SUBQ.n30 20.0353
R533 SUBQ.n413 SUBQ.n32 20.0353
R534 SUBQ.n398 SUBQ.n32 20.0353
R535 SUBQ.n398 SUBQ.n45 20.0353
R536 SUBQ.n394 SUBQ.n45 20.0353
R537 SUBQ.n394 SUBQ.n47 20.0353
R538 SUBQ.n381 SUBQ.n47 20.0353
R539 SUBQ.n381 SUBQ.n56 20.0353
R540 SUBQ.n377 SUBQ.n56 20.0353
R541 SUBQ.n377 SUBQ.n58 20.0353
R542 SUBQ.n364 SUBQ.n58 20.0353
R543 SUBQ.n364 SUBQ.n67 20.0353
R544 SUBQ.n72 SUBQ.n67 20.0353
R545 SUBQ.n357 SUBQ.n72 20.0353
R546 SUBQ.n357 SUBQ.n71 20.0353
R547 SUBQ.n344 SUBQ.n71 20.0353
R548 SUBQ.n344 SUBQ.n85 20.0353
R549 SUBQ.n340 SUBQ.n85 20.0353
R550 SUBQ.n340 SUBQ.n87 20.0353
R551 SUBQ.n328 SUBQ.n87 20.0353
R552 SUBQ.n328 SUBQ.n98 20.0353
R553 SUBQ.n324 SUBQ.n98 20.0353
R554 SUBQ.n324 SUBQ.n100 20.0353
R555 SUBQ.n312 SUBQ.n100 20.0353
R556 SUBQ.n312 SUBQ.n110 20.0353
R557 SUBQ.n307 SUBQ.n110 20.0353
R558 SUBQ.n307 SUBQ.n112 20.0353
R559 SUBQ.n295 SUBQ.n112 20.0353
R560 SUBQ.n295 SUBQ.n122 20.0353
R561 SUBQ.n291 SUBQ.n122 20.0353
R562 SUBQ.n291 SUBQ.n124 20.0353
R563 SUBQ.n279 SUBQ.n124 20.0353
R564 SUBQ.n279 SUBQ.n134 20.0353
R565 SUBQ.n275 SUBQ.n134 20.0353
R566 SUBQ.n275 SUBQ.n136 20.0353
R567 SUBQ.n263 SUBQ.n136 20.0353
R568 SUBQ.n263 SUBQ.n147 20.0353
R569 SUBQ.n259 SUBQ.n147 20.0353
R570 SUBQ.n259 SUBQ.n149 20.0353
R571 SUBQ.n247 SUBQ.n149 20.0353
R572 SUBQ.n247 SUBQ.n160 20.0353
R573 SUBQ.n243 SUBQ.n160 20.0353
R574 SUBQ.n243 SUBQ.n162 20.0353
R575 SUBQ.n474 SUBQ.n4 20.0353
R576 SUBQ.n468 SUBQ.n4 20.0353
R577 SUBQ.n468 SUBQ.n16 20.0353
R578 SUBQ.n463 SUBQ.n16 20.0353
R579 SUBQ.n463 SUBQ.n461 20.0353
R580 SUBQ.n461 SUBQ.n458 20.0353
R581 SUBQ.n458 SUBQ.n18 20.0353
R582 SUBQ.n454 SUBQ.n18 20.0353
R583 SUBQ.n454 SUBQ.n451 20.0353
R584 SUBQ.n451 SUBQ.n448 20.0353
R585 SUBQ.n448 SUBQ.n20 20.0353
R586 SUBQ.n444 SUBQ.n20 20.0353
R587 SUBQ.n444 SUBQ.n441 20.0353
R588 SUBQ.n441 SUBQ.n438 20.0353
R589 SUBQ.n438 SUBQ.n22 20.0353
R590 SUBQ.n434 SUBQ.n22 20.0353
R591 SUBQ.n434 SUBQ.n431 20.0353
R592 SUBQ.n431 SUBQ.n428 20.0353
R593 SUBQ.n428 SUBQ.n24 20.0353
R594 SUBQ.n424 SUBQ.n26 20.0353
R595 SUBQ.n405 SUBQ.n26 20.0353
R596 SUBQ.n405 SUBQ.n39 20.0353
R597 SUBQ.n409 SUBQ.n39 20.0353
R598 SUBQ.n409 SUBQ.n38 20.0353
R599 SUBQ.n402 SUBQ.n38 20.0353
R600 SUBQ.n402 SUBQ.n41 20.0353
R601 SUBQ.n390 SUBQ.n41 20.0353
R602 SUBQ.n390 SUBQ.n50 20.0353
R603 SUBQ.n386 SUBQ.n50 20.0353
R604 SUBQ.n386 SUBQ.n52 20.0353
R605 SUBQ.n373 SUBQ.n52 20.0353
R606 SUBQ.n373 SUBQ.n61 20.0353
R607 SUBQ.n369 SUBQ.n61 20.0353
R608 SUBQ.n369 SUBQ.n63 20.0353
R609 SUBQ.n80 SUBQ.n63 20.0353
R610 SUBQ.n353 SUBQ.n80 20.0353
R611 SUBQ.n353 SUBQ.n79 20.0353
R612 SUBQ.n348 SUBQ.n79 20.0353
R613 SUBQ.n348 SUBQ.n82 20.0353
R614 SUBQ.n336 SUBQ.n82 20.0353
R615 SUBQ.n336 SUBQ.n92 20.0353
R616 SUBQ.n332 SUBQ.n92 20.0353
R617 SUBQ.n332 SUBQ.n94 20.0353
R618 SUBQ.n320 SUBQ.n94 20.0353
R619 SUBQ.n320 SUBQ.n104 20.0353
R620 SUBQ.n316 SUBQ.n104 20.0353
R621 SUBQ.n316 SUBQ.n106 20.0353
R622 SUBQ.n303 SUBQ.n106 20.0353
R623 SUBQ.n303 SUBQ.n117 20.0353
R624 SUBQ.n299 SUBQ.n117 20.0353
R625 SUBQ.n299 SUBQ.n119 20.0353
R626 SUBQ.n287 SUBQ.n119 20.0353
R627 SUBQ.n287 SUBQ.n129 20.0353
R628 SUBQ.n283 SUBQ.n129 20.0353
R629 SUBQ.n283 SUBQ.n131 20.0353
R630 SUBQ.n271 SUBQ.n131 20.0353
R631 SUBQ.n271 SUBQ.n141 20.0353
R632 SUBQ.n267 SUBQ.n141 20.0353
R633 SUBQ.n267 SUBQ.n143 20.0353
R634 SUBQ.n255 SUBQ.n143 20.0353
R635 SUBQ.n255 SUBQ.n154 20.0353
R636 SUBQ.n251 SUBQ.n154 20.0353
R637 SUBQ.n251 SUBQ.n156 20.0353
R638 SUBQ.n239 SUBQ.n156 20.0353
R639 SUBQ.n239 SUBQ.n166 20.0353
R640 SUBQ.n209 SUBQ.n206 20.0353
R641 SUBQ.n210 SUBQ.n209 20.0353
R642 SUBQ.n211 SUBQ.n210 20.0353
R643 SUBQ.n211 SUBQ.n186 20.0353
R644 SUBQ.n215 SUBQ.n186 20.0353
R645 SUBQ.n216 SUBQ.n215 20.0353
R646 SUBQ.n217 SUBQ.n216 20.0353
R647 SUBQ.n217 SUBQ.n181 20.0353
R648 SUBQ.n221 SUBQ.n181 20.0353
R649 SUBQ.n222 SUBQ.n221 20.0353
R650 SUBQ.n223 SUBQ.n222 20.0353
R651 SUBQ.n223 SUBQ.n176 20.0353
R652 SUBQ.n227 SUBQ.n176 20.0353
R653 SUBQ.n228 SUBQ.n227 20.0353
R654 SUBQ.n229 SUBQ.n228 20.0353
R655 SUBQ.n229 SUBQ.n171 20.0353
R656 SUBQ.n233 SUBQ.n171 20.0353
R657 SUBQ.n234 SUBQ.n233 20.0353
R658 SUBQ.n235 SUBQ.n234 20.0353
R659 SUBQ.n90 SUBQ.t2 11.61
R660 SUBQ.t3 SUBQ.n96 11.61
R661 SUBQ.n364 SUBQ.n363 9.3005
R662 SUBQ.n58 SUBQ.n57 9.3005
R663 SUBQ.n378 SUBQ.n377 9.3005
R664 SUBQ.n379 SUBQ.n56 9.3005
R665 SUBQ.n381 SUBQ.n380 9.3005
R666 SUBQ.n47 SUBQ.n46 9.3005
R667 SUBQ.n395 SUBQ.n394 9.3005
R668 SUBQ.n396 SUBQ.n45 9.3005
R669 SUBQ.n398 SUBQ.n397 9.3005
R670 SUBQ.n32 SUBQ.n31 9.3005
R671 SUBQ.n414 SUBQ.n413 9.3005
R672 SUBQ.n415 SUBQ.n30 9.3005
R673 SUBQ.n417 SUBQ.n416 9.3005
R674 SUBQ.n2 SUBQ.n1 9.3005
R675 SUBQ.n476 SUBQ.n475 9.3005
R676 SUBQ.n426 SUBQ.n24 9.3005
R677 SUBQ.n428 SUBQ.n427 9.3005
R678 SUBQ.n431 SUBQ.n23 9.3005
R679 SUBQ.n435 SUBQ.n434 9.3005
R680 SUBQ.n436 SUBQ.n22 9.3005
R681 SUBQ.n438 SUBQ.n437 9.3005
R682 SUBQ.n441 SUBQ.n21 9.3005
R683 SUBQ.n445 SUBQ.n444 9.3005
R684 SUBQ.n446 SUBQ.n20 9.3005
R685 SUBQ.n448 SUBQ.n447 9.3005
R686 SUBQ.n451 SUBQ.n19 9.3005
R687 SUBQ.n455 SUBQ.n454 9.3005
R688 SUBQ.n456 SUBQ.n18 9.3005
R689 SUBQ.n458 SUBQ.n457 9.3005
R690 SUBQ.n461 SUBQ.n17 9.3005
R691 SUBQ.n464 SUBQ.n463 9.3005
R692 SUBQ.n465 SUBQ.n16 9.3005
R693 SUBQ.n468 SUBQ.n467 9.3005
R694 SUBQ.n466 SUBQ.n4 9.3005
R695 SUBQ.n474 SUBQ.n0 9.3005
R696 SUBQ.n425 SUBQ.n424 9.3005
R697 SUBQ.n26 SUBQ.n25 9.3005
R698 SUBQ.n406 SUBQ.n405 9.3005
R699 SUBQ.n407 SUBQ.n39 9.3005
R700 SUBQ.n409 SUBQ.n408 9.3005
R701 SUBQ.n404 SUBQ.n38 9.3005
R702 SUBQ.n403 SUBQ.n402 9.3005
R703 SUBQ.n41 SUBQ.n40 9.3005
R704 SUBQ.n390 SUBQ.n389 9.3005
R705 SUBQ.n388 SUBQ.n50 9.3005
R706 SUBQ.n387 SUBQ.n386 9.3005
R707 SUBQ.n52 SUBQ.n51 9.3005
R708 SUBQ.n373 SUBQ.n372 9.3005
R709 SUBQ.n371 SUBQ.n61 9.3005
R710 SUBQ.n370 SUBQ.n369 9.3005
R711 SUBQ.n63 SUBQ.n62 9.3005
R712 SUBQ.n351 SUBQ.n80 9.3005
R713 SUBQ.n353 SUBQ.n352 9.3005
R714 SUBQ.n350 SUBQ.n79 9.3005
R715 SUBQ.n349 SUBQ.n348 9.3005
R716 SUBQ.n82 SUBQ.n81 9.3005
R717 SUBQ.n336 SUBQ.n335 9.3005
R718 SUBQ.n334 SUBQ.n92 9.3005
R719 SUBQ.n333 SUBQ.n332 9.3005
R720 SUBQ.n94 SUBQ.n93 9.3005
R721 SUBQ.n320 SUBQ.n319 9.3005
R722 SUBQ.n318 SUBQ.n104 9.3005
R723 SUBQ.n317 SUBQ.n316 9.3005
R724 SUBQ.n106 SUBQ.n105 9.3005
R725 SUBQ.n303 SUBQ.n302 9.3005
R726 SUBQ.n301 SUBQ.n117 9.3005
R727 SUBQ.n300 SUBQ.n299 9.3005
R728 SUBQ.n119 SUBQ.n118 9.3005
R729 SUBQ.n287 SUBQ.n286 9.3005
R730 SUBQ.n285 SUBQ.n129 9.3005
R731 SUBQ.n284 SUBQ.n283 9.3005
R732 SUBQ.n131 SUBQ.n130 9.3005
R733 SUBQ.n271 SUBQ.n270 9.3005
R734 SUBQ.n269 SUBQ.n141 9.3005
R735 SUBQ.n268 SUBQ.n267 9.3005
R736 SUBQ.n143 SUBQ.n142 9.3005
R737 SUBQ.n255 SUBQ.n254 9.3005
R738 SUBQ.n253 SUBQ.n154 9.3005
R739 SUBQ.n252 SUBQ.n251 9.3005
R740 SUBQ.n156 SUBQ.n155 9.3005
R741 SUBQ.n239 SUBQ.n238 9.3005
R742 SUBQ.n237 SUBQ.n166 9.3005
R743 SUBQ.n207 SUBQ.n206 9.3005
R744 SUBQ.n209 SUBQ.n208 9.3005
R745 SUBQ.n210 SUBQ.n187 9.3005
R746 SUBQ.n212 SUBQ.n211 9.3005
R747 SUBQ.n213 SUBQ.n186 9.3005
R748 SUBQ.n215 SUBQ.n214 9.3005
R749 SUBQ.n216 SUBQ.n182 9.3005
R750 SUBQ.n218 SUBQ.n217 9.3005
R751 SUBQ.n219 SUBQ.n181 9.3005
R752 SUBQ.n221 SUBQ.n220 9.3005
R753 SUBQ.n222 SUBQ.n177 9.3005
R754 SUBQ.n224 SUBQ.n223 9.3005
R755 SUBQ.n225 SUBQ.n176 9.3005
R756 SUBQ.n227 SUBQ.n226 9.3005
R757 SUBQ.n228 SUBQ.n172 9.3005
R758 SUBQ.n230 SUBQ.n229 9.3005
R759 SUBQ.n231 SUBQ.n171 9.3005
R760 SUBQ.n233 SUBQ.n232 9.3005
R761 SUBQ.n234 SUBQ.n167 9.3005
R762 SUBQ.n236 SUBQ.n235 9.3005
R763 SUBQ.n162 SUBQ.n161 9.3005
R764 SUBQ.n244 SUBQ.n243 9.3005
R765 SUBQ.n245 SUBQ.n160 9.3005
R766 SUBQ.n247 SUBQ.n246 9.3005
R767 SUBQ.n149 SUBQ.n148 9.3005
R768 SUBQ.n260 SUBQ.n259 9.3005
R769 SUBQ.n261 SUBQ.n147 9.3005
R770 SUBQ.n263 SUBQ.n262 9.3005
R771 SUBQ.n309 SUBQ.n110 9.3005
R772 SUBQ.n312 SUBQ.n311 9.3005
R773 SUBQ.n136 SUBQ.n135 9.3005
R774 SUBQ.n276 SUBQ.n275 9.3005
R775 SUBQ.n277 SUBQ.n134 9.3005
R776 SUBQ.n279 SUBQ.n278 9.3005
R777 SUBQ.n124 SUBQ.n123 9.3005
R778 SUBQ.n292 SUBQ.n291 9.3005
R779 SUBQ.n293 SUBQ.n122 9.3005
R780 SUBQ.n295 SUBQ.n294 9.3005
R781 SUBQ.n112 SUBQ.n111 9.3005
R782 SUBQ.n308 SUBQ.n307 9.3005
R783 SUBQ.n100 SUBQ.n99 9.3005
R784 SUBQ.n325 SUBQ.n324 9.3005
R785 SUBQ.n326 SUBQ.n98 9.3005
R786 SUBQ.n328 SUBQ.n327 9.3005
R787 SUBQ.n87 SUBQ.n86 9.3005
R788 SUBQ.n341 SUBQ.n340 9.3005
R789 SUBQ.n342 SUBQ.n85 9.3005
R790 SUBQ.n344 SUBQ.n343 9.3005
R791 SUBQ.n71 SUBQ.n70 9.3005
R792 SUBQ.n358 SUBQ.n357 9.3005
R793 SUBQ.n72 SUBQ.n68 9.3005
R794 SUBQ.n362 SUBQ.n67 9.3005
R795 SUBQ.n361 SUBQ.n360 4.5005
R796 SUBQ.n360 SUBQ.n359 4.5005
R797 SUBQ.n426 SUBQ.n425 0.454304
R798 SUBQ.n237 SUBQ.n236 0.451587
R799 SUBQ.n207 SUBQ.n161 0.451587
R800 SUBQ.n477 SUBQ.n0 0.288543
R801 SUBQ.n476 SUBQ.n1 0.196152
R802 SUBQ.n416 SUBQ.n1 0.196152
R803 SUBQ.n416 SUBQ.n415 0.196152
R804 SUBQ.n415 SUBQ.n414 0.196152
R805 SUBQ.n414 SUBQ.n31 0.196152
R806 SUBQ.n397 SUBQ.n31 0.196152
R807 SUBQ.n397 SUBQ.n396 0.196152
R808 SUBQ.n396 SUBQ.n395 0.196152
R809 SUBQ.n395 SUBQ.n46 0.196152
R810 SUBQ.n380 SUBQ.n46 0.196152
R811 SUBQ.n380 SUBQ.n379 0.196152
R812 SUBQ.n379 SUBQ.n378 0.196152
R813 SUBQ.n378 SUBQ.n57 0.196152
R814 SUBQ.n363 SUBQ.n57 0.196152
R815 SUBQ.n466 SUBQ.n0 0.196152
R816 SUBQ.n467 SUBQ.n466 0.196152
R817 SUBQ.n467 SUBQ.n465 0.196152
R818 SUBQ.n465 SUBQ.n464 0.196152
R819 SUBQ.n464 SUBQ.n17 0.196152
R820 SUBQ.n457 SUBQ.n17 0.196152
R821 SUBQ.n457 SUBQ.n456 0.196152
R822 SUBQ.n456 SUBQ.n455 0.196152
R823 SUBQ.n455 SUBQ.n19 0.196152
R824 SUBQ.n447 SUBQ.n19 0.196152
R825 SUBQ.n447 SUBQ.n446 0.196152
R826 SUBQ.n446 SUBQ.n445 0.196152
R827 SUBQ.n445 SUBQ.n21 0.196152
R828 SUBQ.n437 SUBQ.n21 0.196152
R829 SUBQ.n437 SUBQ.n436 0.196152
R830 SUBQ.n436 SUBQ.n435 0.196152
R831 SUBQ.n435 SUBQ.n23 0.196152
R832 SUBQ.n427 SUBQ.n23 0.196152
R833 SUBQ.n427 SUBQ.n426 0.196152
R834 SUBQ.n425 SUBQ.n25 0.196152
R835 SUBQ.n406 SUBQ.n25 0.196152
R836 SUBQ.n407 SUBQ.n406 0.196152
R837 SUBQ.n408 SUBQ.n407 0.196152
R838 SUBQ.n408 SUBQ.n404 0.196152
R839 SUBQ.n404 SUBQ.n403 0.196152
R840 SUBQ.n403 SUBQ.n40 0.196152
R841 SUBQ.n389 SUBQ.n40 0.196152
R842 SUBQ.n389 SUBQ.n388 0.196152
R843 SUBQ.n388 SUBQ.n387 0.196152
R844 SUBQ.n387 SUBQ.n51 0.196152
R845 SUBQ.n372 SUBQ.n51 0.196152
R846 SUBQ.n372 SUBQ.n371 0.196152
R847 SUBQ.n371 SUBQ.n370 0.196152
R848 SUBQ.n370 SUBQ.n62 0.196152
R849 SUBQ.n351 SUBQ.n62 0.196152
R850 SUBQ.n352 SUBQ.n351 0.196152
R851 SUBQ.n352 SUBQ.n350 0.196152
R852 SUBQ.n350 SUBQ.n349 0.196152
R853 SUBQ.n349 SUBQ.n81 0.196152
R854 SUBQ.n335 SUBQ.n81 0.196152
R855 SUBQ.n335 SUBQ.n334 0.196152
R856 SUBQ.n334 SUBQ.n333 0.196152
R857 SUBQ.n333 SUBQ.n93 0.196152
R858 SUBQ.n319 SUBQ.n93 0.196152
R859 SUBQ.n319 SUBQ.n318 0.196152
R860 SUBQ.n318 SUBQ.n317 0.196152
R861 SUBQ.n317 SUBQ.n105 0.196152
R862 SUBQ.n302 SUBQ.n105 0.196152
R863 SUBQ.n302 SUBQ.n301 0.196152
R864 SUBQ.n301 SUBQ.n300 0.196152
R865 SUBQ.n300 SUBQ.n118 0.196152
R866 SUBQ.n286 SUBQ.n118 0.196152
R867 SUBQ.n286 SUBQ.n285 0.196152
R868 SUBQ.n285 SUBQ.n284 0.196152
R869 SUBQ.n284 SUBQ.n130 0.196152
R870 SUBQ.n270 SUBQ.n130 0.196152
R871 SUBQ.n270 SUBQ.n269 0.196152
R872 SUBQ.n269 SUBQ.n268 0.196152
R873 SUBQ.n268 SUBQ.n142 0.196152
R874 SUBQ.n254 SUBQ.n142 0.196152
R875 SUBQ.n254 SUBQ.n253 0.196152
R876 SUBQ.n253 SUBQ.n252 0.196152
R877 SUBQ.n252 SUBQ.n155 0.196152
R878 SUBQ.n238 SUBQ.n155 0.196152
R879 SUBQ.n238 SUBQ.n237 0.196152
R880 SUBQ.n208 SUBQ.n207 0.196152
R881 SUBQ.n208 SUBQ.n187 0.196152
R882 SUBQ.n212 SUBQ.n187 0.196152
R883 SUBQ.n213 SUBQ.n212 0.196152
R884 SUBQ.n214 SUBQ.n213 0.196152
R885 SUBQ.n214 SUBQ.n182 0.196152
R886 SUBQ.n218 SUBQ.n182 0.196152
R887 SUBQ.n219 SUBQ.n218 0.196152
R888 SUBQ.n220 SUBQ.n219 0.196152
R889 SUBQ.n220 SUBQ.n177 0.196152
R890 SUBQ.n224 SUBQ.n177 0.196152
R891 SUBQ.n225 SUBQ.n224 0.196152
R892 SUBQ.n226 SUBQ.n225 0.196152
R893 SUBQ.n226 SUBQ.n172 0.196152
R894 SUBQ.n230 SUBQ.n172 0.196152
R895 SUBQ.n231 SUBQ.n230 0.196152
R896 SUBQ.n232 SUBQ.n231 0.196152
R897 SUBQ.n232 SUBQ.n167 0.196152
R898 SUBQ.n236 SUBQ.n167 0.196152
R899 SUBQ.n261 SUBQ.n260 0.196152
R900 SUBQ.n260 SUBQ.n148 0.196152
R901 SUBQ.n246 SUBQ.n148 0.196152
R902 SUBQ.n246 SUBQ.n245 0.196152
R903 SUBQ.n245 SUBQ.n244 0.196152
R904 SUBQ.n244 SUBQ.n161 0.196152
R905 SUBQ.n308 SUBQ.n111 0.196152
R906 SUBQ.n294 SUBQ.n111 0.196152
R907 SUBQ.n294 SUBQ.n293 0.196152
R908 SUBQ.n293 SUBQ.n292 0.196152
R909 SUBQ.n292 SUBQ.n123 0.196152
R910 SUBQ.n278 SUBQ.n123 0.196152
R911 SUBQ.n278 SUBQ.n277 0.196152
R912 SUBQ.n277 SUBQ.n276 0.196152
R913 SUBQ.n276 SUBQ.n135 0.196152
R914 SUBQ.n358 SUBQ.n70 0.196152
R915 SUBQ.n343 SUBQ.n70 0.196152
R916 SUBQ.n343 SUBQ.n342 0.196152
R917 SUBQ.n342 SUBQ.n341 0.196152
R918 SUBQ.n341 SUBQ.n86 0.196152
R919 SUBQ.n327 SUBQ.n86 0.196152
R920 SUBQ.n327 SUBQ.n326 0.196152
R921 SUBQ.n326 SUBQ.n325 0.196152
R922 SUBQ.n325 SUBQ.n99 0.196152
R923 SUBQ.n363 SUBQ.n362 0.19333
R924 SUBQ.n309 SUBQ.n308 0.187373
R925 SUBQ.n311 SUBQ.n99 0.186746
R926 SUBQ.n477 SUBQ.n476 0.166261
R927 SUBQ.n262 SUBQ.n135 0.147239
R928 SUBQ.n359 SUBQ.n358 0.142327
R929 SUBQ.n361 SUBQ.n68 0.115885
R930 SUBQ.n310 SUBQ.n309 0.0886495
R931 SUBQ.n311 SUBQ.n310 0.0838418
R932 SUBQ.n262 SUBQ.n261 0.0657174
R933 SUBQ.n362 SUBQ.n361 0.0581923
R934 SUBQ SUBQ.n477 0.0548478
R935 SUBQ.n359 SUBQ.n68 0.0389615
C50 VQUIET SUBQ 1.29765f
C51 VGND SUBQ 3.81233f
C52 OUT SUBQ 1.42217f
C53 VDPWR SUBQ 2.94205f
C54 a_1213_745# SUBQ 0.78838f **FLOATING
C55 a_1213_1039# SUBQ 0.53042f **FLOATING
C56 a_175_745# SUBQ 0.94262f **FLOATING
C57 a_2915_1039# SUBQ 0.75237f **FLOATING
C58 a_1213_1333# SUBQ 0.52677f **FLOATING
C59 a_1213_1627# SUBQ 0.52616f **FLOATING
C60 a_175_1333# SUBQ 0.76706f **FLOATING
C61 a_2915_1627# SUBQ 0.93652f **FLOATING
C62 a_1213_1921# SUBQ 0.77071f **FLOATING
C63 VDPWR.t0 SUBQ 0.03406f **FLOATING
C64 OUT.t1 SUBQ 0.00888f **FLOATING
C65 OUT.t0 SUBQ 0.00888f **FLOATING
C66 OUT.n0 SUBQ 0.02205f **FLOATING
C67 OUT.t2 SUBQ 0.09069f **FLOATING
C68 OUT.n1 SUBQ 0.70476f **FLOATING
C69 VGND.t12 SUBQ 0.00971f **FLOATING
C70 VGND.t11 SUBQ 0.03256f **FLOATING
C71 VGND.t8 SUBQ 0.03256f **FLOATING
C72 VGND.n0 SUBQ 0.03356f **FLOATING
C73 VGND.t13 SUBQ 0.00276f **FLOATING
C74 VGND.t9 SUBQ 0.00276f **FLOATING
C75 VGND.n1 SUBQ 0.00564f **FLOATING
C76 VGND.n2 SUBQ 0.01378f **FLOATING
C77 VGND.n3 SUBQ 0.0992f **FLOATING
C78 VGND.t10 SUBQ 0.00968f **FLOATING
C79 VGND.n4 SUBQ 0.05316f **FLOATING
C80 VGND.t0 SUBQ 0.00968f **FLOATING
C81 VGND.n5 SUBQ 0.0697f **FLOATING
C82 VGND.t1 SUBQ 0.00968f **FLOATING
C83 VGND.n6 SUBQ 0.0697f **FLOATING
C84 VGND.t6 SUBQ 0.00968f **FLOATING
C85 VGND.n7 SUBQ 0.05311f **FLOATING
C86 VGND.t5 SUBQ 0.03256f **FLOATING
C87 VGND.t2 SUBQ 0.03256f **FLOATING
C88 VGND.n8 SUBQ 0.03356f **FLOATING
C89 VGND.t7 SUBQ 0.00276f **FLOATING
C90 VGND.t3 SUBQ 0.00276f **FLOATING
C91 VGND.n9 SUBQ 0.00564f **FLOATING
C92 VGND.n10 SUBQ 0.01378f **FLOATING
C93 VGND.n11 SUBQ 0.04132f **FLOATING
C94 VGND.t4 SUBQ 0.00968f **FLOATING
C95 VGND.n12 SUBQ 0.04384f **FLOATING
C96 VQUIET.n0 SUBQ 0.01499f **FLOATING
C97 VQUIET.n1 SUBQ 0.00606f **FLOATING
C98 VQUIET.n2 SUBQ 0.00702f **FLOATING
C99 VQUIET.t0 SUBQ 0.10897f **FLOATING
C100 VQUIET.n3 SUBQ 0.01024f **FLOATING
C101 VQUIET.n4 SUBQ 0.08258f **FLOATING
C102 VQUIET.n5 SUBQ 0.00415f **FLOATING
C103 VQUIET.n6 SUBQ 0.02114f **FLOATING
C104 VQUIET.n7 SUBQ 0.0342f **FLOATING
C105 VQUIET.n8 SUBQ 0.07237f **FLOATING
C106 VQUIET.n9 SUBQ 0.0151f **FLOATING
C107 VQUIET.n10 SUBQ 0.00606f **FLOATING
C108 VQUIET.n11 SUBQ 0.00702f **FLOATING
C109 VQUIET.t1 SUBQ 0.10897f **FLOATING
C110 VQUIET.n12 SUBQ 0.02091f **FLOATING
C111 VQUIET.n13 SUBQ 0.00415f **FLOATING
C112 VQUIET.n14 SUBQ 0.08258f **FLOATING
C113 VQUIET.n15 SUBQ 0.01024f **FLOATING
C114 VQUIET.n16 SUBQ 0.01482f **FLOATING
C115 VQUIET.n17 SUBQ 0.0151f **FLOATING
C116 VQUIET.n18 SUBQ 0.10517f **FLOATING
