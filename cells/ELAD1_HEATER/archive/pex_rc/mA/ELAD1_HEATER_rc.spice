* SPICE3 file created from ELAD1_HEATER_flat.ext - technology: sky130A

X0 a_118_844.t13 HEN.t27 VGND.t30 VGND.t29 sky130_fd_pr__nfet_01v8 ad=0.25 pd=1.5 as=0.25 ps=1.5 w=1 l=0.15
X1 a_118_844.t3 HEN.t37 VGND.t12 VGND.t11 sky130_fd_pr__nfet_01v8 ad=0.25 pd=1.5 as=0.25 ps=1.5 w=1 l=0.15
X2 VGND.t38 HEN.t24 a_118_844.t16 VGND.t37 sky130_fd_pr__nfet_01v8 ad=0.25 pd=1.5 as=0.25 ps=1.5 w=1 l=0.15
X3 HIN.t1 a_5726_844# VGND.t0 sky130_fd_pr__res_high_po_5p73 l=26.02
X4 VGND.t28 HEN.t28 a_118_844.t12 VGND.t27 sky130_fd_pr__nfet_01v8 ad=0.25 pd=1.5 as=0.25 ps=1.5 w=1 l=0.15
X5 VGND.t10 HEN.t38 a_118_844.t2 VGND.t9 sky130_fd_pr__nfet_01v8 ad=0.25 pd=1.5 as=0.25 ps=1.5 w=1 l=0.15
X6 a_118_844.t19 HEN.t21 VGND.t42 VGND.t41 sky130_fd_pr__nfet_01v8 ad=0.25 pd=1.5 as=0.25 ps=1.5 w=1 l=0.15
X7 a_118_844.t7 HEN.t33 VGND.t20 VGND.t19 sky130_fd_pr__nfet_01v8 ad=0.25 pd=1.5 as=0.25 ps=1.5 w=1 l=0.15
X8 a_118_844.t11 HEN.t29 VGND.t26 VGND.t25 sky130_fd_pr__nfet_01v8 ad=0.25 pd=1.5 as=0.25 ps=1.5 w=1 l=0.15
X9 a_118_844.t15 HEN.t25 VGND.t36 VGND.t35 sky130_fd_pr__nfet_01v8 ad=0.25 pd=1.5 as=0.25 ps=1.5 w=1 l=0.15
X10 VGND.t40 HEN.t22 a_118_844.t18 VGND.t39 sky130_fd_pr__nfet_01v8 ad=0.25 pd=1.5 as=0.25 ps=1.5 w=1 l=0.15
X11 VGND.t16 HEN.t34 a_118_844.t6 VGND.t15 sky130_fd_pr__nfet_01v8 ad=0.25 pd=1.5 as=0.25 ps=1.5 w=1 l=0.15
X12 VGND.t24 HEN.t30 a_118_844.t10 VGND.t23 sky130_fd_pr__nfet_01v8 ad=0.25 pd=1.5 as=0.25 ps=1.5 w=1 l=0.15
X13 a_118_844.t0 a_5726_3376# VGND.t0 sky130_fd_pr__res_high_po_5p73 l=26.02
X14 a_118_844.t5 HEN.t35 VGND.t14 VGND.t13 sky130_fd_pr__nfet_01v8 ad=0.25 pd=1.5 as=0.25 ps=1.5 w=1 l=0.15
X15 a_118_844.t9 HEN.t31 VGND.t22 VGND.t21 sky130_fd_pr__nfet_01v8 ad=0.25 pd=1.5 as=0.25 ps=1.5 w=1 l=0.15
X16 VGND.t18 HEN.t32 a_118_844.t8 VGND.t17 sky130_fd_pr__nfet_01v8 ad=0.25 pd=1.5 as=0.25 ps=1.5 w=1 l=0.15
X17 a_118_844.t41 a_5726_844# VGND.t0 sky130_fd_pr__res_high_po_5p73 l=26.02
X18 a_118_844.t37 HEN.t3 VGND.t76 VGND.t75 sky130_fd_pr__nfet_01v8 ad=0.25 pd=1.5 as=0.25 ps=1.5 w=1 l=0.15
X19 VGND.t74 HEN.t4 a_118_844.t36 VGND.t73 sky130_fd_pr__nfet_01v8 ad=0.25 pd=1.5 as=0.25 ps=1.5 w=1 l=0.15
X20 VGND.t80 HEN.t0 a_118_844.t40 VGND.t79 sky130_fd_pr__nfet_01v8 ad=0.5 pd=3 as=0.25 ps=1.5 w=1 l=0.15
X21 a_118_844.t39 HEN.t1 VGND.t78 VGND.t77 sky130_fd_pr__nfet_01v8 ad=0.25 pd=1.5 as=0.25 ps=1.5 w=1 l=0.15
X22 a_118_844.t31 HEN.t9 VGND.t66 VGND.t65 sky130_fd_pr__nfet_01v8 ad=0.25 pd=1.5 as=0.25 ps=1.5 w=1 l=0.15
X23 a_118_844.t35 HEN.t5 VGND.t70 VGND.t69 sky130_fd_pr__nfet_01v8 ad=0.25 pd=1.5 as=0.25 ps=1.5 w=1 l=0.15
X24 HIN.t0 a_5726_3376# VGND.t0 sky130_fd_pr__res_high_po_5p73 l=26.02
X25 VGND.t62 HEN.t6 a_118_844.t34 VGND.t61 sky130_fd_pr__nfet_01v8 ad=0.25 pd=1.5 as=0.25 ps=1.5 w=1 l=0.15
X26 VGND.t72 HEN.t2 a_118_844.t38 VGND.t71 sky130_fd_pr__nfet_01v8 ad=0.25 pd=1.5 as=0.25 ps=1.5 w=1 l=0.15
X27 VGND.t60 HEN.t10 a_118_844.t30 VGND.t59 sky130_fd_pr__nfet_01v8 ad=0.25 pd=1.5 as=0.25 ps=1.5 w=1 l=0.15
X28 a_118_844.t21 HEN.t19 VGND.t44 VGND.t43 sky130_fd_pr__nfet_01v8 ad=0.25 pd=1.5 as=0.25 ps=1.5 w=1 l=0.15
X29 a_118_844.t29 HEN.t11 VGND.t58 VGND.t57 sky130_fd_pr__nfet_01v8 ad=0.25 pd=1.5 as=0.25 ps=1.5 w=1 l=0.15
X30 a_118_844.t33 HEN.t7 VGND.t64 VGND.t63 sky130_fd_pr__nfet_01v8 ad=0.25 pd=1.5 as=0.25 ps=1.5 w=1 l=0.15
X31 VGND.t6 HEN.t20 a_118_844.t20 VGND.t5 sky130_fd_pr__nfet_01v8 ad=0.25 pd=1.5 as=0.25 ps=1.5 w=1 l=0.15
X32 VGND.t50 HEN.t16 a_118_844.t24 VGND.t49 sky130_fd_pr__nfet_01v8 ad=0.25 pd=1.5 as=0.25 ps=1.5 w=1 l=0.15
X33 VGND.t56 HEN.t12 a_118_844.t28 VGND.t55 sky130_fd_pr__nfet_01v8 ad=0.25 pd=1.5 as=0.25 ps=1.5 w=1 l=0.15
X34 VGND.t68 HEN.t8 a_118_844.t32 VGND.t67 sky130_fd_pr__nfet_01v8 ad=0.25 pd=1.5 as=0.25 ps=1.5 w=1 l=0.15
X35 a_118_844.t23 HEN.t17 VGND.t48 VGND.t47 sky130_fd_pr__nfet_01v8 ad=0.25 pd=1.5 as=0.25 ps=1.5 w=1 l=0.15
X36 a_118_844.t27 HEN.t13 VGND.t54 VGND.t53 sky130_fd_pr__nfet_01v8 ad=0.25 pd=1.5 as=0.25 ps=1.5 w=1 l=0.15
X37 a_118_844.t1 HEN.t39 VGND.t8 VGND.t7 sky130_fd_pr__nfet_01v8 ad=0.25 pd=1.5 as=0.5 ps=3 w=1 l=0.15
X38 VGND.t32 HEN.t26 a_118_844.t14 VGND.t31 sky130_fd_pr__nfet_01v8 ad=0.25 pd=1.5 as=0.25 ps=1.5 w=1 l=0.15
X39 VGND.t46 HEN.t18 a_118_844.t22 VGND.t45 sky130_fd_pr__nfet_01v8 ad=0.25 pd=1.5 as=0.25 ps=1.5 w=1 l=0.15
X40 VGND.t52 HEN.t14 a_118_844.t26 VGND.t51 sky130_fd_pr__nfet_01v8 ad=0.25 pd=1.5 as=0.25 ps=1.5 w=1 l=0.15
X41 VGND.t2 HEN.t36 a_118_844.t4 VGND.t1 sky130_fd_pr__nfet_01v8 ad=0.25 pd=1.5 as=0.25 ps=1.5 w=1 l=0.15
X42 a_118_844.t17 HEN.t23 VGND.t34 VGND.t33 sky130_fd_pr__nfet_01v8 ad=0.25 pd=1.5 as=0.25 ps=1.5 w=1 l=0.15
X43 a_118_844.t25 HEN.t15 VGND.t4 VGND.t3 sky130_fd_pr__nfet_01v8 ad=0.25 pd=1.5 as=0.25 ps=1.5 w=1 l=0.15
C0 a_5726_3376# a_5726_844# 0.1856f
C1 HEN HIN 0
R0 HEN.n0 HEN.t0 416.043
R1 HEN.n0 HEN.t1 415.69
R2 HEN.n1 HEN.t2 415.69
R3 HEN.n2 HEN.t3 415.69
R4 HEN.n3 HEN.t4 415.69
R5 HEN.n4 HEN.t5 415.69
R6 HEN.n5 HEN.t6 415.69
R7 HEN.n6 HEN.t7 415.69
R8 HEN.n7 HEN.t8 415.69
R9 HEN.n8 HEN.t9 415.69
R10 HEN.n9 HEN.t10 415.69
R11 HEN.n10 HEN.t11 415.69
R12 HEN.n11 HEN.t12 415.69
R13 HEN.n12 HEN.t13 415.69
R14 HEN.n13 HEN.t14 415.69
R15 HEN.n14 HEN.t15 415.69
R16 HEN.n15 HEN.t16 415.69
R17 HEN.n16 HEN.t17 415.69
R18 HEN.n17 HEN.t18 415.69
R19 HEN.n18 HEN.t19 415.69
R20 HEN.n19 HEN.t20 415.69
R21 HEN.n20 HEN.t21 415.69
R22 HEN.n21 HEN.t22 415.69
R23 HEN.n22 HEN.t23 415.69
R24 HEN.n23 HEN.t24 415.69
R25 HEN.n24 HEN.t25 415.69
R26 HEN.n25 HEN.t26 415.69
R27 HEN.n26 HEN.t27 415.69
R28 HEN.n27 HEN.t28 415.69
R29 HEN.n28 HEN.t29 415.69
R30 HEN.n29 HEN.t30 415.69
R31 HEN.n30 HEN.t31 415.69
R32 HEN.n31 HEN.t32 415.69
R33 HEN.n32 HEN.t33 415.69
R34 HEN.n33 HEN.t34 415.69
R35 HEN.n34 HEN.t35 415.69
R36 HEN.n35 HEN.t36 415.69
R37 HEN.n36 HEN.t37 415.69
R38 HEN.n37 HEN.t38 415.69
R39 HEN.n38 HEN.t39 415.69
R40 HEN HEN.n38 8.39052
R41 HEN.n37 HEN.n36 0.353761
R42 HEN.n36 HEN.n35 0.353761
R43 HEN.n35 HEN.n34 0.353761
R44 HEN.n34 HEN.n33 0.353761
R45 HEN.n33 HEN.n32 0.353761
R46 HEN.n32 HEN.n31 0.353761
R47 HEN.n31 HEN.n30 0.353761
R48 HEN.n30 HEN.n29 0.353761
R49 HEN.n29 HEN.n28 0.353761
R50 HEN.n28 HEN.n27 0.353761
R51 HEN.n27 HEN.n26 0.353761
R52 HEN.n26 HEN.n25 0.353761
R53 HEN.n25 HEN.n24 0.353761
R54 HEN.n24 HEN.n23 0.353761
R55 HEN.n23 HEN.n22 0.353761
R56 HEN.n22 HEN.n21 0.353761
R57 HEN.n21 HEN.n20 0.353761
R58 HEN.n20 HEN.n19 0.353761
R59 HEN.n19 HEN.n18 0.353761
R60 HEN.n18 HEN.n17 0.353761
R61 HEN.n17 HEN.n16 0.353761
R62 HEN.n16 HEN.n15 0.353761
R63 HEN.n15 HEN.n14 0.353761
R64 HEN.n14 HEN.n13 0.353761
R65 HEN.n13 HEN.n12 0.353761
R66 HEN.n12 HEN.n11 0.353761
R67 HEN.n11 HEN.n10 0.353761
R68 HEN.n10 HEN.n9 0.353761
R69 HEN.n9 HEN.n8 0.353761
R70 HEN.n8 HEN.n7 0.353761
R71 HEN.n7 HEN.n6 0.353761
R72 HEN.n6 HEN.n5 0.353761
R73 HEN.n5 HEN.n4 0.353761
R74 HEN.n4 HEN.n3 0.353761
R75 HEN.n3 HEN.n2 0.353761
R76 HEN.n2 HEN.n1 0.353761
R77 HEN.n1 HEN.n0 0.353761
R78 HEN.n38 HEN.n37 0.343879
R79 HIN.n0 HIN.t0 9.06473
R80 HIN.n0 HIN.t1 9.06473
R81 HIN HIN.n0 0.111214
R82 VGND.n1177 VGND.n10 21867
R83 VGND.n1176 VGND.n1175 1420.8
R84 VGND.n783 VGND.n307 749.457
R85 VGND.n1179 VGND.n3 668.087
R86 VGND.n781 VGND.n310 668.087
R87 VGND.n310 VGND.n308 585
R88 VGND.n311 VGND.n310 585
R89 VGND.n776 VGND.n775 585
R90 VGND.n773 VGND.n313 585
R91 VGND.n772 VGND.n308 585
R92 VGND.n772 VGND.n771 585
R93 VGND.n315 VGND.n314 585
R94 VGND.n767 VGND.n766 585
R95 VGND.n764 VGND.n317 585
R96 VGND.n762 VGND.n761 585
R97 VGND.n782 VGND.n781 585
R98 VGND.n781 VGND.n780 585
R99 VGND.n301 VGND.n300 585
R100 VGND.n300 VGND.n299 585
R101 VGND.n791 VGND.n790 585
R102 VGND.n792 VGND.n791 585
R103 VGND.n296 VGND.n294 585
R104 VGND.n297 VGND.n296 585
R105 VGND.n799 VGND.n798 585
R106 VGND.n798 VGND.n797 585
R107 VGND.n287 VGND.n286 585
R108 VGND.n286 VGND.n285 585
R109 VGND.n808 VGND.n807 585
R110 VGND.n809 VGND.n808 585
R111 VGND.n282 VGND.n280 585
R112 VGND.n283 VGND.n282 585
R113 VGND.n816 VGND.n815 585
R114 VGND.n815 VGND.n814 585
R115 VGND.n273 VGND.n272 585
R116 VGND.n272 VGND.n271 585
R117 VGND.n825 VGND.n824 585
R118 VGND.n826 VGND.n825 585
R119 VGND.n267 VGND.n265 585
R120 VGND.n268 VGND.n267 585
R121 VGND.n833 VGND.n832 585
R122 VGND.n832 VGND.n831 585
R123 VGND.n333 VGND.n257 585
R124 VGND.n257 VGND.n256 585
R125 VGND.n842 VGND.n841 585
R126 VGND.n843 VGND.n842 585
R127 VGND.n259 VGND.n252 585
R128 VGND.n253 VGND.n252 585
R129 VGND.n851 VGND.n850 585
R130 VGND.n850 VGND.n849 585
R131 VGND.n251 VGND.n242 585
R132 VGND.n242 VGND.n241 585
R133 VGND.n860 VGND.n859 585
R134 VGND.n861 VGND.n860 585
R135 VGND.n244 VGND.n238 585
R136 VGND.n239 VGND.n238 585
R137 VGND.n869 VGND.n868 585
R138 VGND.n868 VGND.n867 585
R139 VGND.n237 VGND.n229 585
R140 VGND.n229 VGND.n228 585
R141 VGND.n878 VGND.n877 585
R142 VGND.n879 VGND.n878 585
R143 VGND.n225 VGND.n223 585
R144 VGND.n226 VGND.n225 585
R145 VGND.n887 VGND.n886 585
R146 VGND.n886 VGND.n885 585
R147 VGND.n216 VGND.n215 585
R148 VGND.n215 VGND.n214 585
R149 VGND.n896 VGND.n895 585
R150 VGND.n897 VGND.n896 585
R151 VGND.n211 VGND.n209 585
R152 VGND.n212 VGND.n211 585
R153 VGND.n905 VGND.n904 585
R154 VGND.n904 VGND.n903 585
R155 VGND.n202 VGND.n201 585
R156 VGND.n201 VGND.n200 585
R157 VGND.n914 VGND.n913 585
R158 VGND.n915 VGND.n914 585
R159 VGND.n351 VGND.n197 585
R160 VGND.n198 VGND.n197 585
R161 VGND.n923 VGND.n922 585
R162 VGND.n922 VGND.n921 585
R163 VGND.n196 VGND.n187 585
R164 VGND.n187 VGND.n186 585
R165 VGND.n932 VGND.n931 585
R166 VGND.n933 VGND.n932 585
R167 VGND.n189 VGND.n183 585
R168 VGND.n184 VGND.n183 585
R169 VGND.n941 VGND.n940 585
R170 VGND.n940 VGND.n939 585
R171 VGND.n182 VGND.n173 585
R172 VGND.n173 VGND.n172 585
R173 VGND.n950 VGND.n949 585
R174 VGND.n951 VGND.n950 585
R175 VGND.n175 VGND.n169 585
R176 VGND.n170 VGND.n169 585
R177 VGND.n960 VGND.n959 585
R178 VGND.n959 VGND.n958 585
R179 VGND.n168 VGND.n160 585
R180 VGND.n160 VGND.n159 585
R181 VGND.n968 VGND.t0 585
R182 VGND.n969 VGND.n968 585
R183 VGND.n155 VGND.n153 585
R184 VGND.n156 VGND.n155 585
R185 VGND.n976 VGND.n975 585
R186 VGND.n975 VGND.n974 585
R187 VGND.n146 VGND.n145 585
R188 VGND.n145 VGND.n144 585
R189 VGND.n985 VGND.n984 585
R190 VGND.n986 VGND.n985 585
R191 VGND.n140 VGND.n138 585
R192 VGND.n141 VGND.n140 585
R193 VGND.n993 VGND.n992 585
R194 VGND.n992 VGND.n991 585
R195 VGND.n131 VGND.n130 585
R196 VGND.n130 VGND.n129 585
R197 VGND.n1002 VGND.n1001 585
R198 VGND.n1003 VGND.n1002 585
R199 VGND.n372 VGND.n125 585
R200 VGND.n126 VGND.n125 585
R201 VGND.n1011 VGND.n1010 585
R202 VGND.n1010 VGND.n1009 585
R203 VGND.n124 VGND.n115 585
R204 VGND.n115 VGND.n114 585
R205 VGND.n1020 VGND.n1019 585
R206 VGND.n1021 VGND.n1020 585
R207 VGND.n117 VGND.n111 585
R208 VGND.n112 VGND.n111 585
R209 VGND.n1029 VGND.n1028 585
R210 VGND.n1028 VGND.n1027 585
R211 VGND.n110 VGND.n101 585
R212 VGND.n101 VGND.n100 585
R213 VGND.n1038 VGND.n1037 585
R214 VGND.n1039 VGND.n1038 585
R215 VGND.n103 VGND.n97 585
R216 VGND.n98 VGND.n97 585
R217 VGND.n1047 VGND.n1046 585
R218 VGND.n1046 VGND.n1045 585
R219 VGND.n89 VGND.n88 585
R220 VGND.n88 VGND.n87 585
R221 VGND.n1056 VGND.n1055 585
R222 VGND.n1057 VGND.n1056 585
R223 VGND.n84 VGND.n82 585
R224 VGND.n85 VGND.n84 585
R225 VGND.n1065 VGND.n1064 585
R226 VGND.n1064 VGND.n1063 585
R227 VGND.n75 VGND.n74 585
R228 VGND.n74 VGND.n73 585
R229 VGND.n1074 VGND.n1073 585
R230 VGND.n1075 VGND.n1074 585
R231 VGND.n70 VGND.n68 585
R232 VGND.n71 VGND.n70 585
R233 VGND.n1083 VGND.n1082 585
R234 VGND.n1082 VGND.n1081 585
R235 VGND.n392 VGND.n60 585
R236 VGND.n60 VGND.n59 585
R237 VGND.n1092 VGND.n1091 585
R238 VGND.n1093 VGND.n1092 585
R239 VGND.n62 VGND.n56 585
R240 VGND.n57 VGND.n56 585
R241 VGND.n1101 VGND.n1100 585
R242 VGND.n1100 VGND.n1099 585
R243 VGND.n55 VGND.n46 585
R244 VGND.n46 VGND.n45 585
R245 VGND.n1110 VGND.n1109 585
R246 VGND.n1111 VGND.n1110 585
R247 VGND.n48 VGND.n42 585
R248 VGND.n43 VGND.n42 585
R249 VGND.n1119 VGND.n1118 585
R250 VGND.n1118 VGND.n1117 585
R251 VGND.n41 VGND.n33 585
R252 VGND.n33 VGND.n32 585
R253 VGND.n1128 VGND.n1127 585
R254 VGND.n1129 VGND.n1128 585
R255 VGND.n27 VGND.n25 585
R256 VGND.n29 VGND.n27 585
R257 VGND.n1140 VGND.n1139 585
R258 VGND.n1139 VGND.n1138 585
R259 VGND.n28 VGND.n18 585
R260 VGND.n30 VGND.n28 585
R261 VGND.n1149 VGND.n19 585
R262 VGND.n1134 VGND.n19 585
R263 VGND.n6 VGND.n5 585
R264 VGND.n5 VGND.n4 585
R265 VGND.n1179 VGND.n1178 585
R266 VGND.n1180 VGND.n1179 585
R267 VGND.n1174 VGND.n13 585
R268 VGND.n1157 VGND.n14 585
R269 VGND.n1170 VGND.n1158 585
R270 VGND.n1169 VGND.n1160 585
R271 VGND.n1168 VGND.n1161 585
R272 VGND.n1166 VGND.n1165 585
R273 VGND.n1164 VGND.n2 585
R274 VGND.n1181 VGND.n3 585
R275 VGND.n782 VGND.n309 585
R276 VGND.n526 VGND.n309 585
R277 VGND.n321 VGND.n301 585
R278 VGND.n525 VGND.n321 585
R279 VGND.n790 VGND.n302 585
R280 VGND.n524 VGND.n302 585
R281 VGND.n322 VGND.n294 585
R282 VGND.n323 VGND.n322 585
R283 VGND.n799 VGND.n295 585
R284 VGND.n520 VGND.n295 585
R285 VGND.n325 VGND.n287 585
R286 VGND.n519 VGND.n325 585
R287 VGND.n807 VGND.n288 585
R288 VGND.n518 VGND.n288 585
R289 VGND.n326 VGND.n280 585
R290 VGND.n327 VGND.n326 585
R291 VGND.n816 VGND.n281 585
R292 VGND.n514 VGND.n281 585
R293 VGND.n329 VGND.n273 585
R294 VGND.n513 VGND.n329 585
R295 VGND.n824 VGND.n274 585
R296 VGND.n512 VGND.n274 585
R297 VGND.n330 VGND.n265 585
R298 VGND.n331 VGND.n330 585
R299 VGND.n833 VGND.n266 585
R300 VGND.n508 VGND.n266 585
R301 VGND.n334 VGND.n333 585
R302 VGND.n507 VGND.n334 585
R303 VGND.n841 VGND.n258 585
R304 VGND.n506 VGND.n258 585
R305 VGND.n335 VGND.n259 585
R306 VGND.n336 VGND.n335 585
R307 VGND.n851 VGND.n250 585
R308 VGND.n502 VGND.n250 585
R309 VGND.n338 VGND.n251 585
R310 VGND.n501 VGND.n338 585
R311 VGND.n859 VGND.n243 585
R312 VGND.n500 VGND.n243 585
R313 VGND.n339 VGND.n244 585
R314 VGND.n340 VGND.n339 585
R315 VGND.n869 VGND.n236 585
R316 VGND.n496 VGND.n236 585
R317 VGND.n342 VGND.n237 585
R318 VGND.n495 VGND.n342 585
R319 VGND.n877 VGND.n230 585
R320 VGND.n494 VGND.n230 585
R321 VGND.n343 VGND.n223 585
R322 VGND.n344 VGND.n343 585
R323 VGND.n887 VGND.n224 585
R324 VGND.n490 VGND.n224 585
R325 VGND.n346 VGND.n216 585
R326 VGND.n489 VGND.n346 585
R327 VGND.n895 VGND.n217 585
R328 VGND.n488 VGND.n217 585
R329 VGND.n347 VGND.n209 585
R330 VGND.n348 VGND.n347 585
R331 VGND.n905 VGND.n210 585
R332 VGND.n484 VGND.n210 585
R333 VGND.n350 VGND.n202 585
R334 VGND.n483 VGND.n350 585
R335 VGND.n913 VGND.n203 585
R336 VGND.n482 VGND.n203 585
R337 VGND.n352 VGND.n351 585
R338 VGND.n353 VGND.n352 585
R339 VGND.n923 VGND.n195 585
R340 VGND.n478 VGND.n195 585
R341 VGND.n355 VGND.n196 585
R342 VGND.n477 VGND.n355 585
R343 VGND.n931 VGND.n188 585
R344 VGND.n476 VGND.n188 585
R345 VGND.n356 VGND.n189 585
R346 VGND.n357 VGND.n356 585
R347 VGND.n941 VGND.n181 585
R348 VGND.n472 VGND.n181 585
R349 VGND.n359 VGND.n182 585
R350 VGND.n471 VGND.n359 585
R351 VGND.n949 VGND.n174 585
R352 VGND.n470 VGND.n174 585
R353 VGND.n360 VGND.n175 585
R354 VGND.n361 VGND.n360 585
R355 VGND.n960 VGND.n167 585
R356 VGND.n466 VGND.n167 585
R357 VGND.n363 VGND.n168 585
R358 VGND.n465 VGND.n363 585
R359 VGND.t0 VGND.n161 585
R360 VGND.n464 VGND.n161 585
R361 VGND.n364 VGND.n153 585
R362 VGND.n365 VGND.n364 585
R363 VGND.n976 VGND.n154 585
R364 VGND.n460 VGND.n154 585
R365 VGND.n367 VGND.n146 585
R366 VGND.n459 VGND.n367 585
R367 VGND.n984 VGND.n147 585
R368 VGND.n458 VGND.n147 585
R369 VGND.n368 VGND.n138 585
R370 VGND.n369 VGND.n368 585
R371 VGND.n993 VGND.n139 585
R372 VGND.n454 VGND.n139 585
R373 VGND.n371 VGND.n131 585
R374 VGND.n453 VGND.n371 585
R375 VGND.n1001 VGND.n132 585
R376 VGND.n452 VGND.n132 585
R377 VGND.n373 VGND.n372 585
R378 VGND.n374 VGND.n373 585
R379 VGND.n1011 VGND.n123 585
R380 VGND.n448 VGND.n123 585
R381 VGND.n376 VGND.n124 585
R382 VGND.n447 VGND.n376 585
R383 VGND.n1019 VGND.n116 585
R384 VGND.n446 VGND.n116 585
R385 VGND.n377 VGND.n117 585
R386 VGND.n378 VGND.n377 585
R387 VGND.n1029 VGND.n109 585
R388 VGND.n442 VGND.n109 585
R389 VGND.n380 VGND.n110 585
R390 VGND.n441 VGND.n380 585
R391 VGND.n1037 VGND.n102 585
R392 VGND.n440 VGND.n102 585
R393 VGND.n381 VGND.n103 585
R394 VGND.n382 VGND.n381 585
R395 VGND.n1047 VGND.n96 585
R396 VGND.n436 VGND.n96 585
R397 VGND.n384 VGND.n89 585
R398 VGND.n435 VGND.n384 585
R399 VGND.n1055 VGND.n90 585
R400 VGND.n434 VGND.n90 585
R401 VGND.n385 VGND.n82 585
R402 VGND.n386 VGND.n385 585
R403 VGND.n1065 VGND.n83 585
R404 VGND.n430 VGND.n83 585
R405 VGND.n388 VGND.n75 585
R406 VGND.n429 VGND.n388 585
R407 VGND.n1073 VGND.n76 585
R408 VGND.n428 VGND.n76 585
R409 VGND.n389 VGND.n68 585
R410 VGND.n390 VGND.n389 585
R411 VGND.n1083 VGND.n69 585
R412 VGND.n424 VGND.n69 585
R413 VGND.n393 VGND.n392 585
R414 VGND.n423 VGND.n393 585
R415 VGND.n1091 VGND.n61 585
R416 VGND.n422 VGND.n61 585
R417 VGND.n394 VGND.n62 585
R418 VGND.n395 VGND.n394 585
R419 VGND.n1101 VGND.n54 585
R420 VGND.n418 VGND.n54 585
R421 VGND.n397 VGND.n55 585
R422 VGND.n417 VGND.n397 585
R423 VGND.n1109 VGND.n47 585
R424 VGND.n416 VGND.n47 585
R425 VGND.n398 VGND.n48 585
R426 VGND.n399 VGND.n398 585
R427 VGND.n1119 VGND.n40 585
R428 VGND.n412 VGND.n40 585
R429 VGND.n401 VGND.n41 585
R430 VGND.n411 VGND.n401 585
R431 VGND.n1127 VGND.n34 585
R432 VGND.n410 VGND.n34 585
R433 VGND.n402 VGND.n25 585
R434 VGND.n403 VGND.n402 585
R435 VGND.n1140 VGND.n26 585
R436 VGND.n406 VGND.n26 585
R437 VGND.n18 VGND.n17 585
R438 VGND.n405 VGND.n17 585
R439 VGND.n1150 VGND.n1149 585
R440 VGND.n1150 VGND.n16 585
R441 VGND.n1151 VGND.n6 585
R442 VGND.n1152 VGND.n1151 585
R443 VGND.n1178 VGND.n7 585
R444 VGND.n12 VGND.n7 585
R445 VGND.n1178 VGND.n1177 585
R446 VGND.n1177 VGND.n1176 585
R447 VGND.n9 VGND.n6 585
R448 VGND.n1146 VGND.n9 585
R449 VGND.n1149 VGND.n1148 585
R450 VGND.n1148 VGND.n1147 585
R451 VGND.n20 VGND.n18 585
R452 VGND.n21 VGND.n20 585
R453 VGND.n1141 VGND.n1140 585
R454 VGND.n1142 VGND.n1141 585
R455 VGND.n25 VGND.n24 585
R456 VGND.n24 VGND.n23 585
R457 VGND.n1127 VGND.n1126 585
R458 VGND.n1126 VGND.n1125 585
R459 VGND.n41 VGND.n35 585
R460 VGND.n36 VGND.n35 585
R461 VGND.n1120 VGND.n1119 585
R462 VGND.n1121 VGND.n1120 585
R463 VGND.n48 VGND.n39 585
R464 VGND.n39 VGND.n38 585
R465 VGND.n1109 VGND.n1108 585
R466 VGND.n1108 VGND.n1107 585
R467 VGND.n55 VGND.n49 585
R468 VGND.n50 VGND.n49 585
R469 VGND.n1102 VGND.n1101 585
R470 VGND.n1103 VGND.n1102 585
R471 VGND.n62 VGND.n53 585
R472 VGND.n53 VGND.n52 585
R473 VGND.n1091 VGND.n1090 585
R474 VGND.n1090 VGND.n1089 585
R475 VGND.n392 VGND.n63 585
R476 VGND.n64 VGND.n63 585
R477 VGND.n1084 VGND.n1083 585
R478 VGND.n1085 VGND.n1084 585
R479 VGND.n68 VGND.n67 585
R480 VGND.n67 VGND.n66 585
R481 VGND.n1073 VGND.n1072 585
R482 VGND.n1072 VGND.n1071 585
R483 VGND.n77 VGND.n75 585
R484 VGND.n78 VGND.n77 585
R485 VGND.n1066 VGND.n1065 585
R486 VGND.n1067 VGND.n1066 585
R487 VGND.n82 VGND.n81 585
R488 VGND.n81 VGND.n80 585
R489 VGND.n1055 VGND.n1054 585
R490 VGND.n1054 VGND.n1053 585
R491 VGND.n91 VGND.n89 585
R492 VGND.n92 VGND.n91 585
R493 VGND.n1048 VGND.n1047 585
R494 VGND.n1049 VGND.n1048 585
R495 VGND.n103 VGND.n95 585
R496 VGND.n95 VGND.n94 585
R497 VGND.n1037 VGND.n1036 585
R498 VGND.n1036 VGND.n1035 585
R499 VGND.n110 VGND.n104 585
R500 VGND.n105 VGND.n104 585
R501 VGND.n1030 VGND.n1029 585
R502 VGND.n1031 VGND.n1030 585
R503 VGND.n117 VGND.n108 585
R504 VGND.n108 VGND.n107 585
R505 VGND.n1019 VGND.n1018 585
R506 VGND.n1018 VGND.n1017 585
R507 VGND.n124 VGND.n118 585
R508 VGND.n119 VGND.n118 585
R509 VGND.n1012 VGND.n1011 585
R510 VGND.n1013 VGND.n1012 585
R511 VGND.n372 VGND.n122 585
R512 VGND.n122 VGND.n121 585
R513 VGND.n1001 VGND.n1000 585
R514 VGND.n1000 VGND.n999 585
R515 VGND.n133 VGND.n131 585
R516 VGND.n134 VGND.n133 585
R517 VGND.n994 VGND.n993 585
R518 VGND.n995 VGND.n994 585
R519 VGND.n138 VGND.n137 585
R520 VGND.n137 VGND.n136 585
R521 VGND.n984 VGND.n983 585
R522 VGND.n983 VGND.n982 585
R523 VGND.n148 VGND.n146 585
R524 VGND.n149 VGND.n148 585
R525 VGND.n977 VGND.n976 585
R526 VGND.n978 VGND.n977 585
R527 VGND.n153 VGND.n152 585
R528 VGND.n152 VGND.n151 585
R529 VGND.t0 VGND.n967 585
R530 VGND.n967 VGND.n966 585
R531 VGND.n168 VGND.n162 585
R532 VGND.n163 VGND.n162 585
R533 VGND.n961 VGND.n960 585
R534 VGND.n962 VGND.n961 585
R535 VGND.n175 VGND.n166 585
R536 VGND.n166 VGND.n165 585
R537 VGND.n949 VGND.n948 585
R538 VGND.n948 VGND.n947 585
R539 VGND.n182 VGND.n176 585
R540 VGND.n177 VGND.n176 585
R541 VGND.n942 VGND.n941 585
R542 VGND.n943 VGND.n942 585
R543 VGND.n189 VGND.n180 585
R544 VGND.n180 VGND.n179 585
R545 VGND.n931 VGND.n930 585
R546 VGND.n930 VGND.n929 585
R547 VGND.n196 VGND.n190 585
R548 VGND.n191 VGND.n190 585
R549 VGND.n924 VGND.n923 585
R550 VGND.n925 VGND.n924 585
R551 VGND.n351 VGND.n194 585
R552 VGND.n194 VGND.n193 585
R553 VGND.n913 VGND.n912 585
R554 VGND.n912 VGND.n911 585
R555 VGND.n204 VGND.n202 585
R556 VGND.n205 VGND.n204 585
R557 VGND.n906 VGND.n905 585
R558 VGND.n907 VGND.n906 585
R559 VGND.n209 VGND.n208 585
R560 VGND.n208 VGND.n207 585
R561 VGND.n895 VGND.n894 585
R562 VGND.n894 VGND.n893 585
R563 VGND.n218 VGND.n216 585
R564 VGND.n219 VGND.n218 585
R565 VGND.n888 VGND.n887 585
R566 VGND.n889 VGND.n888 585
R567 VGND.n223 VGND.n222 585
R568 VGND.n222 VGND.n221 585
R569 VGND.n877 VGND.n876 585
R570 VGND.n876 VGND.n875 585
R571 VGND.n237 VGND.n231 585
R572 VGND.n232 VGND.n231 585
R573 VGND.n870 VGND.n869 585
R574 VGND.n871 VGND.n870 585
R575 VGND.n244 VGND.n235 585
R576 VGND.n235 VGND.n234 585
R577 VGND.n859 VGND.n858 585
R578 VGND.n858 VGND.n857 585
R579 VGND.n251 VGND.n245 585
R580 VGND.n246 VGND.n245 585
R581 VGND.n852 VGND.n851 585
R582 VGND.n853 VGND.n852 585
R583 VGND.n259 VGND.n249 585
R584 VGND.n249 VGND.n248 585
R585 VGND.n841 VGND.n840 585
R586 VGND.n840 VGND.n839 585
R587 VGND.n333 VGND.n260 585
R588 VGND.n261 VGND.n260 585
R589 VGND.n834 VGND.n833 585
R590 VGND.n835 VGND.n834 585
R591 VGND.n265 VGND.n264 585
R592 VGND.n264 VGND.n263 585
R593 VGND.n824 VGND.n823 585
R594 VGND.n823 VGND.n822 585
R595 VGND.n275 VGND.n273 585
R596 VGND.n276 VGND.n275 585
R597 VGND.n817 VGND.n816 585
R598 VGND.n818 VGND.n817 585
R599 VGND.n280 VGND.n279 585
R600 VGND.n279 VGND.n278 585
R601 VGND.n807 VGND.n806 585
R602 VGND.n806 VGND.n805 585
R603 VGND.n289 VGND.n287 585
R604 VGND.n290 VGND.n289 585
R605 VGND.n800 VGND.n799 585
R606 VGND.n801 VGND.n800 585
R607 VGND.n294 VGND.n293 585
R608 VGND.n293 VGND.n292 585
R609 VGND.n790 VGND.n789 585
R610 VGND.n789 VGND.n788 585
R611 VGND.n303 VGND.n301 585
R612 VGND.n304 VGND.n303 585
R613 VGND.n783 VGND.n782 585
R614 VGND.n784 VGND.n783 585
R615 VGND.n756 VGND.n308 585
R616 VGND.n757 VGND.n756 585
R617 VGND.n755 VGND.n529 585
R618 VGND.n753 VGND.n752 585
R619 VGND.n531 VGND.n530 585
R620 VGND.n748 VGND.n747 585
R621 VGND.n745 VGND.n533 585
R622 VGND.n743 VGND.n742 585
R623 VGND.n535 VGND.n534 585
R624 VGND.n738 VGND.n737 585
R625 VGND.n735 VGND.n537 585
R626 VGND.n733 VGND.n732 585
R627 VGND.n539 VGND.n538 585
R628 VGND.n728 VGND.n727 585
R629 VGND.n725 VGND.n541 585
R630 VGND.n723 VGND.n722 585
R631 VGND.n543 VGND.n542 585
R632 VGND.n718 VGND.n717 585
R633 VGND.n715 VGND.n545 585
R634 VGND.n713 VGND.n712 585
R635 VGND.n547 VGND.n546 585
R636 VGND.n708 VGND.n707 585
R637 VGND.n705 VGND.n549 585
R638 VGND.n703 VGND.n702 585
R639 VGND.n550 VGND.n308 585
R640 VGND.n551 VGND.n550 585
R641 VGND.n698 VGND.n697 585
R642 VGND.n695 VGND.n553 585
R643 VGND.n694 VGND.n693 585
R644 VGND.n687 VGND.n555 585
R645 VGND.n688 VGND.n308 585
R646 VGND.n689 VGND.n688 585
R647 VGND.n686 VGND.n557 585
R648 VGND.n684 VGND.n683 585
R649 VGND.n559 VGND.n558 585
R650 VGND.n679 VGND.n678 585
R651 VGND.n676 VGND.n561 585
R652 VGND.n674 VGND.n673 585
R653 VGND.n562 VGND.n308 585
R654 VGND.n563 VGND.n562 585
R655 VGND.n669 VGND.n668 585
R656 VGND.n666 VGND.n565 585
R657 VGND.n665 VGND.n664 585
R658 VGND.n658 VGND.n567 585
R659 VGND.n659 VGND.n308 585
R660 VGND.n660 VGND.n659 585
R661 VGND.n657 VGND.n569 585
R662 VGND.n655 VGND.n654 585
R663 VGND.n570 VGND.n308 585
R664 VGND.n571 VGND.n570 585
R665 VGND.n650 VGND.n649 585
R666 VGND.n647 VGND.n573 585
R667 VGND.n646 VGND.n308 585
R668 VGND.n646 VGND.n645 585
R669 VGND.n575 VGND.n574 585
R670 VGND.n641 VGND.n640 585
R671 VGND.n638 VGND.n577 585
R672 VGND.n636 VGND.n635 585
R673 VGND.n579 VGND.n578 585
R674 VGND.n631 VGND.n630 585
R675 VGND.n628 VGND.n581 585
R676 VGND.n626 VGND.n625 585
R677 VGND.n583 VGND.n582 585
R678 VGND.n621 VGND.n620 585
R679 VGND.n618 VGND.n308 585
R680 VGND.n618 VGND.n585 585
R681 VGND.n617 VGND.n616 585
R682 VGND.n590 VGND.n587 585
R683 VGND.n612 VGND.n611 585
R684 VGND.n609 VGND.n589 585
R685 VGND.n608 VGND.n607 585
R686 VGND.n601 VGND.n592 585
R687 VGND.n603 VGND.n602 585
R688 VGND.n599 VGND.n594 585
R689 VGND.n598 VGND.n597 585
R690 VGND.n307 VGND.n306 585
R691 VGND.n756 VGND.n318 458.24
R692 VGND.n13 VGND.n10 376.87
R693 VGND.n762 VGND.n318 376.87
R694 VGND.n1151 VGND.n7 308.349
R695 VGND.n1151 VGND.n1150 308.349
R696 VGND.n1150 VGND.n17 308.349
R697 VGND.n26 VGND.n17 308.349
R698 VGND.n402 VGND.n26 308.349
R699 VGND.n402 VGND.n34 308.349
R700 VGND.n401 VGND.n34 308.349
R701 VGND.n401 VGND.n40 308.349
R702 VGND.n398 VGND.n40 308.349
R703 VGND.n398 VGND.n47 308.349
R704 VGND.n397 VGND.n47 308.349
R705 VGND.n397 VGND.n54 308.349
R706 VGND.n394 VGND.n54 308.349
R707 VGND.n394 VGND.n61 308.349
R708 VGND.n393 VGND.n61 308.349
R709 VGND.n393 VGND.n69 308.349
R710 VGND.n389 VGND.n69 308.349
R711 VGND.n389 VGND.n76 308.349
R712 VGND.n388 VGND.n76 308.349
R713 VGND.n388 VGND.n83 308.349
R714 VGND.n385 VGND.n83 308.349
R715 VGND.n385 VGND.n90 308.349
R716 VGND.n384 VGND.n90 308.349
R717 VGND.n384 VGND.n96 308.349
R718 VGND.n381 VGND.n96 308.349
R719 VGND.n381 VGND.n102 308.349
R720 VGND.n380 VGND.n102 308.349
R721 VGND.n380 VGND.n109 308.349
R722 VGND.n377 VGND.n109 308.349
R723 VGND.n377 VGND.n116 308.349
R724 VGND.n376 VGND.n116 308.349
R725 VGND.n376 VGND.n123 308.349
R726 VGND.n373 VGND.n123 308.349
R727 VGND.n373 VGND.n132 308.349
R728 VGND.n371 VGND.n132 308.349
R729 VGND.n371 VGND.n139 308.349
R730 VGND.n368 VGND.n139 308.349
R731 VGND.n368 VGND.n147 308.349
R732 VGND.n367 VGND.n147 308.349
R733 VGND.n367 VGND.n154 308.349
R734 VGND.n364 VGND.n154 308.349
R735 VGND.n364 VGND.n161 308.349
R736 VGND.n363 VGND.n161 308.349
R737 VGND.n363 VGND.n167 308.349
R738 VGND.n360 VGND.n167 308.349
R739 VGND.n360 VGND.n174 308.349
R740 VGND.n359 VGND.n174 308.349
R741 VGND.n359 VGND.n181 308.349
R742 VGND.n356 VGND.n181 308.349
R743 VGND.n356 VGND.n188 308.349
R744 VGND.n355 VGND.n188 308.349
R745 VGND.n355 VGND.n195 308.349
R746 VGND.n352 VGND.n195 308.349
R747 VGND.n352 VGND.n203 308.349
R748 VGND.n350 VGND.n203 308.349
R749 VGND.n350 VGND.n210 308.349
R750 VGND.n347 VGND.n210 308.349
R751 VGND.n347 VGND.n217 308.349
R752 VGND.n346 VGND.n217 308.349
R753 VGND.n346 VGND.n224 308.349
R754 VGND.n343 VGND.n224 308.349
R755 VGND.n343 VGND.n230 308.349
R756 VGND.n342 VGND.n230 308.349
R757 VGND.n342 VGND.n236 308.349
R758 VGND.n339 VGND.n236 308.349
R759 VGND.n339 VGND.n243 308.349
R760 VGND.n338 VGND.n243 308.349
R761 VGND.n338 VGND.n250 308.349
R762 VGND.n335 VGND.n250 308.349
R763 VGND.n335 VGND.n258 308.349
R764 VGND.n334 VGND.n258 308.349
R765 VGND.n334 VGND.n266 308.349
R766 VGND.n330 VGND.n266 308.349
R767 VGND.n330 VGND.n274 308.349
R768 VGND.n329 VGND.n274 308.349
R769 VGND.n329 VGND.n281 308.349
R770 VGND.n326 VGND.n281 308.349
R771 VGND.n326 VGND.n288 308.349
R772 VGND.n325 VGND.n288 308.349
R773 VGND.n325 VGND.n295 308.349
R774 VGND.n322 VGND.n295 308.349
R775 VGND.n322 VGND.n302 308.349
R776 VGND.n321 VGND.n302 308.349
R777 VGND.n321 VGND.n309 308.349
R778 VGND.n1165 VGND.n1164 308.349
R779 VGND.n1161 VGND.n1160 308.349
R780 VGND.n1158 VGND.n1157 308.349
R781 VGND.n1177 VGND.n9 308.349
R782 VGND.n1148 VGND.n9 308.349
R783 VGND.n1148 VGND.n20 308.349
R784 VGND.n1141 VGND.n20 308.349
R785 VGND.n1141 VGND.n24 308.349
R786 VGND.n1126 VGND.n24 308.349
R787 VGND.n1126 VGND.n35 308.349
R788 VGND.n1120 VGND.n35 308.349
R789 VGND.n1120 VGND.n39 308.349
R790 VGND.n1108 VGND.n39 308.349
R791 VGND.n1108 VGND.n49 308.349
R792 VGND.n1102 VGND.n49 308.349
R793 VGND.n1102 VGND.n53 308.349
R794 VGND.n1090 VGND.n53 308.349
R795 VGND.n1090 VGND.n63 308.349
R796 VGND.n1084 VGND.n63 308.349
R797 VGND.n1084 VGND.n67 308.349
R798 VGND.n1072 VGND.n67 308.349
R799 VGND.n1072 VGND.n77 308.349
R800 VGND.n1066 VGND.n77 308.349
R801 VGND.n1066 VGND.n81 308.349
R802 VGND.n1054 VGND.n81 308.349
R803 VGND.n1054 VGND.n91 308.349
R804 VGND.n1048 VGND.n91 308.349
R805 VGND.n1048 VGND.n95 308.349
R806 VGND.n1036 VGND.n95 308.349
R807 VGND.n1036 VGND.n104 308.349
R808 VGND.n1030 VGND.n104 308.349
R809 VGND.n1030 VGND.n108 308.349
R810 VGND.n1018 VGND.n108 308.349
R811 VGND.n1018 VGND.n118 308.349
R812 VGND.n1012 VGND.n118 308.349
R813 VGND.n1012 VGND.n122 308.349
R814 VGND.n1000 VGND.n122 308.349
R815 VGND.n1000 VGND.n133 308.349
R816 VGND.n994 VGND.n133 308.349
R817 VGND.n994 VGND.n137 308.349
R818 VGND.n983 VGND.n137 308.349
R819 VGND.n983 VGND.n148 308.349
R820 VGND.n977 VGND.n148 308.349
R821 VGND.n977 VGND.n152 308.349
R822 VGND.n967 VGND.n152 308.349
R823 VGND.n967 VGND.n162 308.349
R824 VGND.n961 VGND.n162 308.349
R825 VGND.n961 VGND.n166 308.349
R826 VGND.n948 VGND.n166 308.349
R827 VGND.n948 VGND.n176 308.349
R828 VGND.n942 VGND.n176 308.349
R829 VGND.n942 VGND.n180 308.349
R830 VGND.n930 VGND.n180 308.349
R831 VGND.n930 VGND.n190 308.349
R832 VGND.n924 VGND.n190 308.349
R833 VGND.n924 VGND.n194 308.349
R834 VGND.n912 VGND.n194 308.349
R835 VGND.n912 VGND.n204 308.349
R836 VGND.n906 VGND.n204 308.349
R837 VGND.n906 VGND.n208 308.349
R838 VGND.n894 VGND.n208 308.349
R839 VGND.n894 VGND.n218 308.349
R840 VGND.n888 VGND.n218 308.349
R841 VGND.n888 VGND.n222 308.349
R842 VGND.n876 VGND.n222 308.349
R843 VGND.n876 VGND.n231 308.349
R844 VGND.n870 VGND.n231 308.349
R845 VGND.n870 VGND.n235 308.349
R846 VGND.n858 VGND.n235 308.349
R847 VGND.n858 VGND.n245 308.349
R848 VGND.n852 VGND.n245 308.349
R849 VGND.n852 VGND.n249 308.349
R850 VGND.n840 VGND.n249 308.349
R851 VGND.n840 VGND.n260 308.349
R852 VGND.n834 VGND.n260 308.349
R853 VGND.n834 VGND.n264 308.349
R854 VGND.n823 VGND.n264 308.349
R855 VGND.n823 VGND.n275 308.349
R856 VGND.n817 VGND.n275 308.349
R857 VGND.n817 VGND.n279 308.349
R858 VGND.n806 VGND.n279 308.349
R859 VGND.n806 VGND.n289 308.349
R860 VGND.n800 VGND.n289 308.349
R861 VGND.n800 VGND.n293 308.349
R862 VGND.n789 VGND.n293 308.349
R863 VGND.n789 VGND.n303 308.349
R864 VGND.n783 VGND.n303 308.349
R865 VGND.n756 VGND.n755 308.349
R866 VGND.n753 VGND.n530 308.349
R867 VGND.n747 VGND.n745 308.349
R868 VGND.n743 VGND.n534 308.349
R869 VGND.n737 VGND.n735 308.349
R870 VGND.n733 VGND.n538 308.349
R871 VGND.n727 VGND.n725 308.349
R872 VGND.n723 VGND.n542 308.349
R873 VGND.n717 VGND.n715 308.349
R874 VGND.n713 VGND.n546 308.349
R875 VGND.n707 VGND.n705 308.349
R876 VGND.n703 VGND.n550 308.349
R877 VGND.n697 VGND.n550 308.349
R878 VGND.n695 VGND.n694 308.349
R879 VGND.n688 VGND.n687 308.349
R880 VGND.n688 VGND.n686 308.349
R881 VGND.n684 VGND.n558 308.349
R882 VGND.n678 VGND.n676 308.349
R883 VGND.n674 VGND.n562 308.349
R884 VGND.n668 VGND.n562 308.349
R885 VGND.n666 VGND.n665 308.349
R886 VGND.n659 VGND.n658 308.349
R887 VGND.n659 VGND.n657 308.349
R888 VGND.n655 VGND.n570 308.349
R889 VGND.n649 VGND.n570 308.349
R890 VGND.n647 VGND.n646 308.349
R891 VGND.n646 VGND.n574 308.349
R892 VGND.n640 VGND.n638 308.349
R893 VGND.n636 VGND.n578 308.349
R894 VGND.n630 VGND.n628 308.349
R895 VGND.n626 VGND.n582 308.349
R896 VGND.n620 VGND.n618 308.349
R897 VGND.n618 VGND.n617 308.349
R898 VGND.n611 VGND.n590 308.349
R899 VGND.n609 VGND.n608 308.349
R900 VGND.n602 VGND.n601 308.349
R901 VGND.n599 VGND.n598 308.349
R902 VGND.n1179 VGND.n5 308.349
R903 VGND.n19 VGND.n5 308.349
R904 VGND.n28 VGND.n19 308.349
R905 VGND.n1139 VGND.n28 308.349
R906 VGND.n1139 VGND.n27 308.349
R907 VGND.n1128 VGND.n27 308.349
R908 VGND.n1128 VGND.n33 308.349
R909 VGND.n1118 VGND.n33 308.349
R910 VGND.n1118 VGND.n42 308.349
R911 VGND.n1110 VGND.n42 308.349
R912 VGND.n1110 VGND.n46 308.349
R913 VGND.n1100 VGND.n46 308.349
R914 VGND.n1100 VGND.n56 308.349
R915 VGND.n1092 VGND.n56 308.349
R916 VGND.n1092 VGND.n60 308.349
R917 VGND.n1082 VGND.n60 308.349
R918 VGND.n1082 VGND.n70 308.349
R919 VGND.n1074 VGND.n70 308.349
R920 VGND.n1074 VGND.n74 308.349
R921 VGND.n1064 VGND.n74 308.349
R922 VGND.n1064 VGND.n84 308.349
R923 VGND.n1056 VGND.n84 308.349
R924 VGND.n1056 VGND.n88 308.349
R925 VGND.n1046 VGND.n88 308.349
R926 VGND.n1046 VGND.n97 308.349
R927 VGND.n1038 VGND.n97 308.349
R928 VGND.n1038 VGND.n101 308.349
R929 VGND.n1028 VGND.n101 308.349
R930 VGND.n1028 VGND.n111 308.349
R931 VGND.n1020 VGND.n111 308.349
R932 VGND.n1020 VGND.n115 308.349
R933 VGND.n1010 VGND.n115 308.349
R934 VGND.n1010 VGND.n125 308.349
R935 VGND.n1002 VGND.n125 308.349
R936 VGND.n1002 VGND.n130 308.349
R937 VGND.n992 VGND.n130 308.349
R938 VGND.n992 VGND.n140 308.349
R939 VGND.n985 VGND.n140 308.349
R940 VGND.n985 VGND.n145 308.349
R941 VGND.n975 VGND.n145 308.349
R942 VGND.n975 VGND.n155 308.349
R943 VGND.n968 VGND.n155 308.349
R944 VGND.n968 VGND.n160 308.349
R945 VGND.n959 VGND.n160 308.349
R946 VGND.n959 VGND.n169 308.349
R947 VGND.n950 VGND.n169 308.349
R948 VGND.n950 VGND.n173 308.349
R949 VGND.n940 VGND.n173 308.349
R950 VGND.n940 VGND.n183 308.349
R951 VGND.n932 VGND.n183 308.349
R952 VGND.n932 VGND.n187 308.349
R953 VGND.n922 VGND.n187 308.349
R954 VGND.n922 VGND.n197 308.349
R955 VGND.n914 VGND.n197 308.349
R956 VGND.n914 VGND.n201 308.349
R957 VGND.n904 VGND.n201 308.349
R958 VGND.n904 VGND.n211 308.349
R959 VGND.n896 VGND.n211 308.349
R960 VGND.n896 VGND.n215 308.349
R961 VGND.n886 VGND.n215 308.349
R962 VGND.n886 VGND.n225 308.349
R963 VGND.n878 VGND.n225 308.349
R964 VGND.n878 VGND.n229 308.349
R965 VGND.n868 VGND.n229 308.349
R966 VGND.n868 VGND.n238 308.349
R967 VGND.n860 VGND.n238 308.349
R968 VGND.n860 VGND.n242 308.349
R969 VGND.n850 VGND.n242 308.349
R970 VGND.n850 VGND.n252 308.349
R971 VGND.n842 VGND.n252 308.349
R972 VGND.n842 VGND.n257 308.349
R973 VGND.n832 VGND.n257 308.349
R974 VGND.n832 VGND.n267 308.349
R975 VGND.n825 VGND.n267 308.349
R976 VGND.n825 VGND.n272 308.349
R977 VGND.n815 VGND.n272 308.349
R978 VGND.n815 VGND.n282 308.349
R979 VGND.n808 VGND.n282 308.349
R980 VGND.n808 VGND.n286 308.349
R981 VGND.n798 VGND.n286 308.349
R982 VGND.n798 VGND.n296 308.349
R983 VGND.n791 VGND.n296 308.349
R984 VGND.n791 VGND.n300 308.349
R985 VGND.n781 VGND.n300 308.349
R986 VGND.n775 VGND.n310 308.349
R987 VGND.n773 VGND.n772 308.349
R988 VGND.n772 VGND.n314 308.349
R989 VGND.n766 VGND.n764 308.349
R990 VGND.n10 VGND.n7 291.217
R991 VGND.n318 VGND.n309 291.217
R992 VGND.n774 VGND.n308 231.493
R993 VGND.n765 VGND.n308 231.493
R994 VGND.n763 VGND.n308 231.493
R995 VGND.n1156 VGND.n8 231.493
R996 VGND.n1159 VGND.n8 231.493
R997 VGND.n1162 VGND.n8 231.493
R998 VGND.n1163 VGND.n8 231.493
R999 VGND.n754 VGND.n308 231.493
R1000 VGND.n746 VGND.n308 231.493
R1001 VGND.n744 VGND.n308 231.493
R1002 VGND.n736 VGND.n308 231.493
R1003 VGND.n734 VGND.n308 231.493
R1004 VGND.n726 VGND.n308 231.493
R1005 VGND.n724 VGND.n308 231.493
R1006 VGND.n716 VGND.n308 231.493
R1007 VGND.n714 VGND.n308 231.493
R1008 VGND.n706 VGND.n308 231.493
R1009 VGND.n704 VGND.n308 231.493
R1010 VGND.n696 VGND.n308 231.493
R1011 VGND.n554 VGND.n308 231.493
R1012 VGND.n685 VGND.n308 231.493
R1013 VGND.n677 VGND.n308 231.493
R1014 VGND.n675 VGND.n308 231.493
R1015 VGND.n667 VGND.n308 231.493
R1016 VGND.n566 VGND.n308 231.493
R1017 VGND.n656 VGND.n308 231.493
R1018 VGND.n648 VGND.n308 231.493
R1019 VGND.n639 VGND.n308 231.493
R1020 VGND.n637 VGND.n308 231.493
R1021 VGND.n629 VGND.n308 231.493
R1022 VGND.n627 VGND.n308 231.493
R1023 VGND.n619 VGND.n308 231.493
R1024 VGND.n586 VGND.n308 231.493
R1025 VGND.n610 VGND.n308 231.493
R1026 VGND.n591 VGND.n308 231.493
R1027 VGND.n600 VGND.n308 231.493
R1028 VGND.n595 VGND.n308 231.493
R1029 VGND.n284 VGND.t80 131.321
R1030 VGND.n1131 VGND.t8 131.321
R1031 VGND.n774 VGND.n773 122.017
R1032 VGND.n765 VGND.n314 122.017
R1033 VGND.n764 VGND.n763 122.017
R1034 VGND.n1156 VGND.n13 122.017
R1035 VGND.n1159 VGND.n1158 122.017
R1036 VGND.n1162 VGND.n1161 122.017
R1037 VGND.n1164 VGND.n1163 122.017
R1038 VGND.n1163 VGND.n3 122.017
R1039 VGND.n1165 VGND.n1162 122.017
R1040 VGND.n1160 VGND.n1159 122.017
R1041 VGND.n1157 VGND.n1156 122.017
R1042 VGND.n754 VGND.n753 122.017
R1043 VGND.n747 VGND.n746 122.017
R1044 VGND.n744 VGND.n743 122.017
R1045 VGND.n737 VGND.n736 122.017
R1046 VGND.n734 VGND.n733 122.017
R1047 VGND.n727 VGND.n726 122.017
R1048 VGND.n725 VGND.n724 122.017
R1049 VGND.n716 VGND.n542 122.017
R1050 VGND.n714 VGND.n713 122.017
R1051 VGND.n707 VGND.n706 122.017
R1052 VGND.n704 VGND.n703 122.017
R1053 VGND.n696 VGND.n695 122.017
R1054 VGND.n687 VGND.n554 122.017
R1055 VGND.n686 VGND.n685 122.017
R1056 VGND.n678 VGND.n677 122.017
R1057 VGND.n675 VGND.n674 122.017
R1058 VGND.n667 VGND.n666 122.017
R1059 VGND.n658 VGND.n566 122.017
R1060 VGND.n656 VGND.n655 122.017
R1061 VGND.n648 VGND.n647 122.017
R1062 VGND.n640 VGND.n639 122.017
R1063 VGND.n637 VGND.n636 122.017
R1064 VGND.n630 VGND.n629 122.017
R1065 VGND.n627 VGND.n626 122.017
R1066 VGND.n620 VGND.n619 122.017
R1067 VGND.n590 VGND.n586 122.017
R1068 VGND.n611 VGND.n610 122.017
R1069 VGND.n601 VGND.n591 122.017
R1070 VGND.n600 VGND.n599 122.017
R1071 VGND.n595 VGND.n307 122.017
R1072 VGND.n755 VGND.n754 122.017
R1073 VGND.n746 VGND.n530 122.017
R1074 VGND.n745 VGND.n744 122.017
R1075 VGND.n736 VGND.n534 122.017
R1076 VGND.n735 VGND.n734 122.017
R1077 VGND.n726 VGND.n538 122.017
R1078 VGND.n724 VGND.n723 122.017
R1079 VGND.n717 VGND.n716 122.017
R1080 VGND.n715 VGND.n714 122.017
R1081 VGND.n706 VGND.n546 122.017
R1082 VGND.n705 VGND.n704 122.017
R1083 VGND.n697 VGND.n696 122.017
R1084 VGND.n694 VGND.n554 122.017
R1085 VGND.n685 VGND.n684 122.017
R1086 VGND.n677 VGND.n558 122.017
R1087 VGND.n676 VGND.n675 122.017
R1088 VGND.n668 VGND.n667 122.017
R1089 VGND.n665 VGND.n566 122.017
R1090 VGND.n657 VGND.n656 122.017
R1091 VGND.n649 VGND.n648 122.017
R1092 VGND.n639 VGND.n574 122.017
R1093 VGND.n638 VGND.n637 122.017
R1094 VGND.n629 VGND.n578 122.017
R1095 VGND.n628 VGND.n627 122.017
R1096 VGND.n619 VGND.n582 122.017
R1097 VGND.n617 VGND.n586 122.017
R1098 VGND.n610 VGND.n609 122.017
R1099 VGND.n608 VGND.n591 122.017
R1100 VGND.n602 VGND.n600 122.017
R1101 VGND.n598 VGND.n595 122.017
R1102 VGND.n775 VGND.n774 122.017
R1103 VGND.n766 VGND.n765 122.017
R1104 VGND.n763 VGND.n762 122.017
R1105 VGND.n270 VGND.n269 101.322
R1106 VGND.n255 VGND.n254 101.322
R1107 VGND.n847 VGND.n846 101.322
R1108 VGND.n865 VGND.n864 101.322
R1109 VGND.n883 VGND.n882 101.322
R1110 VGND.n901 VGND.n900 101.322
R1111 VGND.n919 VGND.n918 101.322
R1112 VGND.n936 VGND.n935 101.322
R1113 VGND.n954 VGND.n953 101.322
R1114 VGND.n158 VGND.n157 101.322
R1115 VGND.n143 VGND.n142 101.322
R1116 VGND.n128 VGND.n127 101.322
R1117 VGND.n1007 VGND.n1006 101.322
R1118 VGND.n1025 VGND.n1024 101.322
R1119 VGND.n1043 VGND.n1042 101.322
R1120 VGND.n1061 VGND.n1060 101.322
R1121 VGND.n1079 VGND.n1078 101.322
R1122 VGND.n1096 VGND.n1095 101.322
R1123 VGND.n1114 VGND.n1113 101.322
R1124 VGND.n1178 VGND.n6 53.6227
R1125 VGND.n1149 VGND.n6 53.6227
R1126 VGND.n1149 VGND.n18 53.6227
R1127 VGND.n1140 VGND.n18 53.6227
R1128 VGND.n1140 VGND.n25 53.6227
R1129 VGND.n1127 VGND.n25 53.6227
R1130 VGND.n1119 VGND.n41 53.6227
R1131 VGND.n1109 VGND.n48 53.6227
R1132 VGND.n1101 VGND.n55 53.6227
R1133 VGND.n1091 VGND.n62 53.6227
R1134 VGND.n1083 VGND.n68 53.6227
R1135 VGND.n1073 VGND.n75 53.6227
R1136 VGND.n1065 VGND.n82 53.6227
R1137 VGND.n1055 VGND.n89 53.6227
R1138 VGND.n1037 VGND.n103 53.6227
R1139 VGND.n1029 VGND.n110 53.6227
R1140 VGND.n1019 VGND.n117 53.6227
R1141 VGND.n1011 VGND.n124 53.6227
R1142 VGND.n1001 VGND.n131 53.6227
R1143 VGND.n993 VGND.n138 53.6227
R1144 VGND.n984 VGND.n146 53.6227
R1145 VGND.n976 VGND.n153 53.6227
R1146 VGND.n960 VGND.n168 53.6227
R1147 VGND.n949 VGND.n175 53.6227
R1148 VGND.n941 VGND.n182 53.6227
R1149 VGND.n931 VGND.n189 53.6227
R1150 VGND.n923 VGND.n196 53.6227
R1151 VGND.n913 VGND.n202 53.6227
R1152 VGND.n905 VGND.n209 53.6227
R1153 VGND.n895 VGND.n216 53.6227
R1154 VGND.n887 VGND.n223 53.6227
R1155 VGND.n869 VGND.n237 53.6227
R1156 VGND.n859 VGND.n244 53.6227
R1157 VGND.n851 VGND.n251 53.6227
R1158 VGND.n841 VGND.n259 53.6227
R1159 VGND.n833 VGND.n265 53.6227
R1160 VGND.n824 VGND.n273 53.6227
R1161 VGND.n816 VGND.n280 53.6227
R1162 VGND.n807 VGND.n287 53.6227
R1163 VGND.n799 VGND.n287 53.6227
R1164 VGND.n799 VGND.n294 53.6227
R1165 VGND.n790 VGND.n294 53.6227
R1166 VGND.n790 VGND.n301 53.6227
R1167 VGND.n782 VGND.n301 53.6227
R1168 VGND.t0 VGND.t43 52.878
R1169 VGND.n351 VGND.t51 52.878
R1170 VGND.n372 VGND.t37 51.3885
R1171 VGND.n877 VGND.t65 51.3885
R1172 VGND.n1178 VGND.n8 50.6437
R1173 VGND.n782 VGND.n308 50.6437
R1174 VGND.n1047 VGND.t25 49.8989
R1175 VGND.n333 VGND.t73 49.8989
R1176 VGND.n784 VGND.n306 48.6961
R1177 VGND.n392 VGND.t13 48.4094
R1178 VGND.n392 VGND.t15 48.4094
R1179 VGND.n1127 VGND.t7 46.9199
R1180 VGND.n1047 VGND.t23 46.9199
R1181 VGND.n333 VGND.t75 46.9199
R1182 VGND.n372 VGND.t35 45.4304
R1183 VGND.n877 VGND.t67 45.4304
R1184 VGND.t0 VGND.t5 43.9409
R1185 VGND.n351 VGND.t53 43.9409
R1186 VGND.n780 VGND.n311 43.4092
R1187 VGND.n1181 VGND.n1180 43.4092
R1188 VGND.n960 VGND.t45 42.4514
R1189 VGND.n196 VGND.t3 42.4514
R1190 VGND.t33 VGND.n131 40.9619
R1191 VGND.n887 VGND.t59 40.9619
R1192 VGND.n1037 VGND.t27 39.4724
R1193 VGND.n259 VGND.t69 39.4724
R1194 VGND.n62 VGND.t1 37.9829
R1195 VGND.t19 VGND.n68 37.9829
R1196 VGND.n807 VGND.t79 37.9829
R1197 VGND.n1119 VGND.t9 36.4934
R1198 VGND.n1055 VGND.t21 36.4934
R1199 VGND.t71 VGND.n265 36.4934
R1200 VGND.n124 VGND.t31 35.0039
R1201 VGND.n869 VGND.t63 35.0039
R1202 VGND.n976 VGND.t41 33.5144
R1203 VGND.t55 VGND.n202 33.5144
R1204 VGND.n949 VGND.t47 32.0249
R1205 VGND.n189 VGND.t49 32.0249
R1206 VGND.t39 VGND.n138 30.5354
R1207 VGND.n895 VGND.t57 30.5354
R1208 VGND.n1113 VGND.t10 30.0005
R1209 VGND.n1113 VGND.t12 30.0005
R1210 VGND.n1095 VGND.t2 30.0005
R1211 VGND.n1095 VGND.t14 30.0005
R1212 VGND.n1078 VGND.t16 30.0005
R1213 VGND.n1078 VGND.t20 30.0005
R1214 VGND.n1060 VGND.t18 30.0005
R1215 VGND.n1060 VGND.t22 30.0005
R1216 VGND.n1042 VGND.t24 30.0005
R1217 VGND.n1042 VGND.t26 30.0005
R1218 VGND.n1024 VGND.t28 30.0005
R1219 VGND.n1024 VGND.t30 30.0005
R1220 VGND.n1006 VGND.t32 30.0005
R1221 VGND.n1006 VGND.t36 30.0005
R1222 VGND.n127 VGND.t38 30.0005
R1223 VGND.n127 VGND.t34 30.0005
R1224 VGND.n142 VGND.t40 30.0005
R1225 VGND.n142 VGND.t42 30.0005
R1226 VGND.n157 VGND.t6 30.0005
R1227 VGND.n157 VGND.t44 30.0005
R1228 VGND.n953 VGND.t46 30.0005
R1229 VGND.n953 VGND.t48 30.0005
R1230 VGND.n935 VGND.t50 30.0005
R1231 VGND.n935 VGND.t4 30.0005
R1232 VGND.n918 VGND.t52 30.0005
R1233 VGND.n918 VGND.t54 30.0005
R1234 VGND.n900 VGND.t56 30.0005
R1235 VGND.n900 VGND.t58 30.0005
R1236 VGND.n882 VGND.t60 30.0005
R1237 VGND.n882 VGND.t66 30.0005
R1238 VGND.n864 VGND.t68 30.0005
R1239 VGND.n864 VGND.t64 30.0005
R1240 VGND.n846 VGND.t62 30.0005
R1241 VGND.n846 VGND.t70 30.0005
R1242 VGND.n254 VGND.t74 30.0005
R1243 VGND.n254 VGND.t76 30.0005
R1244 VGND.n269 VGND.t72 30.0005
R1245 VGND.n269 VGND.t78 30.0005
R1246 VGND.n757 VGND.n319 29.7744
R1247 VGND.n1029 VGND.t29 29.0459
R1248 VGND.n251 VGND.t61 29.0459
R1249 VGND.n55 VGND.t11 27.5564
R1250 VGND.t17 VGND.n75 27.5564
R1251 VGND.n816 VGND.t77 27.5564
R1252 VGND.n1109 VGND.t11 26.0669
R1253 VGND.n1065 VGND.t17 26.0669
R1254 VGND.t77 VGND.n273 26.0669
R1255 VGND.n117 VGND.t29 24.5773
R1256 VGND.n859 VGND.t61 24.5773
R1257 VGND.n761 VGND.n319 24.4875
R1258 VGND.n1175 VGND.n1174 24.4875
R1259 VGND.n984 VGND.t39 23.0878
R1260 VGND.t57 VGND.n209 23.0878
R1261 VGND.n182 VGND.t47 21.5983
R1262 VGND.n941 VGND.t49 21.5983
R1263 VGND.t41 VGND.n146 20.1088
R1264 VGND.n905 VGND.t55 20.1088
R1265 VGND.n776 VGND.n313 20.0353
R1266 VGND.n771 VGND.n313 20.0353
R1267 VGND.n771 VGND.n315 20.0353
R1268 VGND.n767 VGND.n315 20.0353
R1269 VGND.n767 VGND.n317 20.0353
R1270 VGND.n761 VGND.n317 20.0353
R1271 VGND.n1180 VGND.n4 20.0353
R1272 VGND.n1134 VGND.n4 20.0353
R1273 VGND.n1134 VGND.n30 20.0353
R1274 VGND.n1138 VGND.n30 20.0353
R1275 VGND.n1138 VGND.n29 20.0353
R1276 VGND.n1129 VGND.n29 20.0353
R1277 VGND.n1129 VGND.n32 20.0353
R1278 VGND.n1117 VGND.n32 20.0353
R1279 VGND.n1117 VGND.n43 20.0353
R1280 VGND.n1111 VGND.n43 20.0353
R1281 VGND.n1111 VGND.n45 20.0353
R1282 VGND.n1099 VGND.n45 20.0353
R1283 VGND.n1099 VGND.n57 20.0353
R1284 VGND.n1093 VGND.n57 20.0353
R1285 VGND.n1093 VGND.n59 20.0353
R1286 VGND.n1081 VGND.n59 20.0353
R1287 VGND.n1081 VGND.n71 20.0353
R1288 VGND.n1075 VGND.n71 20.0353
R1289 VGND.n1075 VGND.n73 20.0353
R1290 VGND.n1063 VGND.n73 20.0353
R1291 VGND.n1063 VGND.n85 20.0353
R1292 VGND.n1057 VGND.n85 20.0353
R1293 VGND.n1057 VGND.n87 20.0353
R1294 VGND.n1045 VGND.n87 20.0353
R1295 VGND.n1045 VGND.n98 20.0353
R1296 VGND.n1039 VGND.n98 20.0353
R1297 VGND.n1039 VGND.n100 20.0353
R1298 VGND.n1027 VGND.n100 20.0353
R1299 VGND.n1027 VGND.n112 20.0353
R1300 VGND.n1021 VGND.n112 20.0353
R1301 VGND.n1021 VGND.n114 20.0353
R1302 VGND.n1009 VGND.n114 20.0353
R1303 VGND.n1009 VGND.n126 20.0353
R1304 VGND.n1003 VGND.n126 20.0353
R1305 VGND.n1003 VGND.n129 20.0353
R1306 VGND.n991 VGND.n129 20.0353
R1307 VGND.n991 VGND.n141 20.0353
R1308 VGND.n986 VGND.n141 20.0353
R1309 VGND.n986 VGND.n144 20.0353
R1310 VGND.n974 VGND.n144 20.0353
R1311 VGND.n974 VGND.n156 20.0353
R1312 VGND.n969 VGND.n156 20.0353
R1313 VGND.n969 VGND.n159 20.0353
R1314 VGND.n958 VGND.n159 20.0353
R1315 VGND.n958 VGND.n170 20.0353
R1316 VGND.n951 VGND.n170 20.0353
R1317 VGND.n951 VGND.n172 20.0353
R1318 VGND.n939 VGND.n172 20.0353
R1319 VGND.n939 VGND.n184 20.0353
R1320 VGND.n933 VGND.n184 20.0353
R1321 VGND.n933 VGND.n186 20.0353
R1322 VGND.n921 VGND.n186 20.0353
R1323 VGND.n921 VGND.n198 20.0353
R1324 VGND.n915 VGND.n198 20.0353
R1325 VGND.n915 VGND.n200 20.0353
R1326 VGND.n903 VGND.n200 20.0353
R1327 VGND.n903 VGND.n212 20.0353
R1328 VGND.n897 VGND.n212 20.0353
R1329 VGND.n897 VGND.n214 20.0353
R1330 VGND.n885 VGND.n214 20.0353
R1331 VGND.n885 VGND.n226 20.0353
R1332 VGND.n879 VGND.n226 20.0353
R1333 VGND.n879 VGND.n228 20.0353
R1334 VGND.n867 VGND.n228 20.0353
R1335 VGND.n867 VGND.n239 20.0353
R1336 VGND.n861 VGND.n239 20.0353
R1337 VGND.n861 VGND.n241 20.0353
R1338 VGND.n849 VGND.n241 20.0353
R1339 VGND.n849 VGND.n253 20.0353
R1340 VGND.n843 VGND.n253 20.0353
R1341 VGND.n843 VGND.n256 20.0353
R1342 VGND.n831 VGND.n256 20.0353
R1343 VGND.n831 VGND.n268 20.0353
R1344 VGND.n826 VGND.n268 20.0353
R1345 VGND.n826 VGND.n271 20.0353
R1346 VGND.n814 VGND.n271 20.0353
R1347 VGND.n814 VGND.n283 20.0353
R1348 VGND.n809 VGND.n283 20.0353
R1349 VGND.n809 VGND.n285 20.0353
R1350 VGND.n797 VGND.n285 20.0353
R1351 VGND.n797 VGND.n297 20.0353
R1352 VGND.n792 VGND.n297 20.0353
R1353 VGND.n792 VGND.n299 20.0353
R1354 VGND.n780 VGND.n299 20.0353
R1355 VGND.n1166 VGND.n2 20.0353
R1356 VGND.n1168 VGND.n1166 20.0353
R1357 VGND.n1169 VGND.n1168 20.0353
R1358 VGND.n1170 VGND.n1169 20.0353
R1359 VGND.n1170 VGND.n14 20.0353
R1360 VGND.n1174 VGND.n14 20.0353
R1361 VGND.n1152 VGND.n12 20.0353
R1362 VGND.n1152 VGND.n16 20.0353
R1363 VGND.n405 VGND.n16 20.0353
R1364 VGND.n406 VGND.n405 20.0353
R1365 VGND.n406 VGND.n403 20.0353
R1366 VGND.n410 VGND.n403 20.0353
R1367 VGND.n411 VGND.n410 20.0353
R1368 VGND.n412 VGND.n411 20.0353
R1369 VGND.n412 VGND.n399 20.0353
R1370 VGND.n416 VGND.n399 20.0353
R1371 VGND.n417 VGND.n416 20.0353
R1372 VGND.n418 VGND.n417 20.0353
R1373 VGND.n418 VGND.n395 20.0353
R1374 VGND.n422 VGND.n395 20.0353
R1375 VGND.n423 VGND.n422 20.0353
R1376 VGND.n424 VGND.n423 20.0353
R1377 VGND.n424 VGND.n390 20.0353
R1378 VGND.n428 VGND.n390 20.0353
R1379 VGND.n429 VGND.n428 20.0353
R1380 VGND.n430 VGND.n429 20.0353
R1381 VGND.n430 VGND.n386 20.0353
R1382 VGND.n434 VGND.n386 20.0353
R1383 VGND.n435 VGND.n434 20.0353
R1384 VGND.n436 VGND.n435 20.0353
R1385 VGND.n436 VGND.n382 20.0353
R1386 VGND.n440 VGND.n382 20.0353
R1387 VGND.n441 VGND.n440 20.0353
R1388 VGND.n442 VGND.n441 20.0353
R1389 VGND.n442 VGND.n378 20.0353
R1390 VGND.n446 VGND.n378 20.0353
R1391 VGND.n447 VGND.n446 20.0353
R1392 VGND.n448 VGND.n447 20.0353
R1393 VGND.n448 VGND.n374 20.0353
R1394 VGND.n452 VGND.n374 20.0353
R1395 VGND.n453 VGND.n452 20.0353
R1396 VGND.n454 VGND.n453 20.0353
R1397 VGND.n454 VGND.n369 20.0353
R1398 VGND.n458 VGND.n369 20.0353
R1399 VGND.n459 VGND.n458 20.0353
R1400 VGND.n460 VGND.n459 20.0353
R1401 VGND.n460 VGND.n365 20.0353
R1402 VGND.n464 VGND.n365 20.0353
R1403 VGND.n465 VGND.n464 20.0353
R1404 VGND.n466 VGND.n465 20.0353
R1405 VGND.n466 VGND.n361 20.0353
R1406 VGND.n470 VGND.n361 20.0353
R1407 VGND.n471 VGND.n470 20.0353
R1408 VGND.n472 VGND.n471 20.0353
R1409 VGND.n472 VGND.n357 20.0353
R1410 VGND.n476 VGND.n357 20.0353
R1411 VGND.n477 VGND.n476 20.0353
R1412 VGND.n478 VGND.n477 20.0353
R1413 VGND.n478 VGND.n353 20.0353
R1414 VGND.n482 VGND.n353 20.0353
R1415 VGND.n483 VGND.n482 20.0353
R1416 VGND.n484 VGND.n483 20.0353
R1417 VGND.n484 VGND.n348 20.0353
R1418 VGND.n488 VGND.n348 20.0353
R1419 VGND.n489 VGND.n488 20.0353
R1420 VGND.n490 VGND.n489 20.0353
R1421 VGND.n490 VGND.n344 20.0353
R1422 VGND.n494 VGND.n344 20.0353
R1423 VGND.n495 VGND.n494 20.0353
R1424 VGND.n496 VGND.n495 20.0353
R1425 VGND.n496 VGND.n340 20.0353
R1426 VGND.n500 VGND.n340 20.0353
R1427 VGND.n501 VGND.n500 20.0353
R1428 VGND.n502 VGND.n501 20.0353
R1429 VGND.n502 VGND.n336 20.0353
R1430 VGND.n506 VGND.n336 20.0353
R1431 VGND.n507 VGND.n506 20.0353
R1432 VGND.n508 VGND.n507 20.0353
R1433 VGND.n508 VGND.n331 20.0353
R1434 VGND.n512 VGND.n331 20.0353
R1435 VGND.n513 VGND.n512 20.0353
R1436 VGND.n514 VGND.n513 20.0353
R1437 VGND.n514 VGND.n327 20.0353
R1438 VGND.n518 VGND.n327 20.0353
R1439 VGND.n519 VGND.n518 20.0353
R1440 VGND.n520 VGND.n519 20.0353
R1441 VGND.n520 VGND.n323 20.0353
R1442 VGND.n524 VGND.n323 20.0353
R1443 VGND.n525 VGND.n524 20.0353
R1444 VGND.n526 VGND.n525 20.0353
R1445 VGND.n757 VGND.n529 20.0353
R1446 VGND.n752 VGND.n529 20.0353
R1447 VGND.n752 VGND.n531 20.0353
R1448 VGND.n748 VGND.n531 20.0353
R1449 VGND.n748 VGND.n533 20.0353
R1450 VGND.n742 VGND.n533 20.0353
R1451 VGND.n742 VGND.n535 20.0353
R1452 VGND.n738 VGND.n535 20.0353
R1453 VGND.n738 VGND.n537 20.0353
R1454 VGND.n732 VGND.n537 20.0353
R1455 VGND.n732 VGND.n539 20.0353
R1456 VGND.n728 VGND.n539 20.0353
R1457 VGND.n728 VGND.n541 20.0353
R1458 VGND.n722 VGND.n541 20.0353
R1459 VGND.n722 VGND.n543 20.0353
R1460 VGND.n718 VGND.n543 20.0353
R1461 VGND.n718 VGND.n545 20.0353
R1462 VGND.n712 VGND.n545 20.0353
R1463 VGND.n712 VGND.n547 20.0353
R1464 VGND.n708 VGND.n547 20.0353
R1465 VGND.n708 VGND.n549 20.0353
R1466 VGND.n702 VGND.n549 20.0353
R1467 VGND.n702 VGND.n551 20.0353
R1468 VGND.n698 VGND.n551 20.0353
R1469 VGND.n698 VGND.n553 20.0353
R1470 VGND.n693 VGND.n553 20.0353
R1471 VGND.n693 VGND.n555 20.0353
R1472 VGND.n689 VGND.n555 20.0353
R1473 VGND.n689 VGND.n557 20.0353
R1474 VGND.n683 VGND.n557 20.0353
R1475 VGND.n683 VGND.n559 20.0353
R1476 VGND.n679 VGND.n559 20.0353
R1477 VGND.n679 VGND.n561 20.0353
R1478 VGND.n673 VGND.n561 20.0353
R1479 VGND.n673 VGND.n563 20.0353
R1480 VGND.n669 VGND.n563 20.0353
R1481 VGND.n669 VGND.n565 20.0353
R1482 VGND.n664 VGND.n565 20.0353
R1483 VGND.n664 VGND.n567 20.0353
R1484 VGND.n660 VGND.n567 20.0353
R1485 VGND.n660 VGND.n569 20.0353
R1486 VGND.n654 VGND.n569 20.0353
R1487 VGND.n654 VGND.n571 20.0353
R1488 VGND.n650 VGND.n571 20.0353
R1489 VGND.n650 VGND.n573 20.0353
R1490 VGND.n645 VGND.n573 20.0353
R1491 VGND.n645 VGND.n575 20.0353
R1492 VGND.n641 VGND.n575 20.0353
R1493 VGND.n641 VGND.n577 20.0353
R1494 VGND.n635 VGND.n577 20.0353
R1495 VGND.n635 VGND.n579 20.0353
R1496 VGND.n631 VGND.n579 20.0353
R1497 VGND.n631 VGND.n581 20.0353
R1498 VGND.n625 VGND.n581 20.0353
R1499 VGND.n625 VGND.n583 20.0353
R1500 VGND.n621 VGND.n583 20.0353
R1501 VGND.n621 VGND.n585 20.0353
R1502 VGND.n616 VGND.n585 20.0353
R1503 VGND.n616 VGND.n587 20.0353
R1504 VGND.n612 VGND.n587 20.0353
R1505 VGND.n612 VGND.n589 20.0353
R1506 VGND.n607 VGND.n589 20.0353
R1507 VGND.n607 VGND.n592 20.0353
R1508 VGND.n603 VGND.n592 20.0353
R1509 VGND.n603 VGND.n594 20.0353
R1510 VGND.n597 VGND.n594 20.0353
R1511 VGND.n597 VGND.n306 20.0353
R1512 VGND.n1147 VGND.n1146 20.0353
R1513 VGND.n1147 VGND.n21 20.0353
R1514 VGND.n1142 VGND.n21 20.0353
R1515 VGND.n1142 VGND.n23 20.0353
R1516 VGND.n1125 VGND.n23 20.0353
R1517 VGND.n1125 VGND.n36 20.0353
R1518 VGND.n1121 VGND.n36 20.0353
R1519 VGND.n1121 VGND.n38 20.0353
R1520 VGND.n1107 VGND.n38 20.0353
R1521 VGND.n1107 VGND.n50 20.0353
R1522 VGND.n1103 VGND.n50 20.0353
R1523 VGND.n1103 VGND.n52 20.0353
R1524 VGND.n1089 VGND.n52 20.0353
R1525 VGND.n1089 VGND.n64 20.0353
R1526 VGND.n1085 VGND.n64 20.0353
R1527 VGND.n1085 VGND.n66 20.0353
R1528 VGND.n1071 VGND.n66 20.0353
R1529 VGND.n1071 VGND.n78 20.0353
R1530 VGND.n1067 VGND.n78 20.0353
R1531 VGND.n1067 VGND.n80 20.0353
R1532 VGND.n1053 VGND.n80 20.0353
R1533 VGND.n1053 VGND.n92 20.0353
R1534 VGND.n1049 VGND.n92 20.0353
R1535 VGND.n1049 VGND.n94 20.0353
R1536 VGND.n1035 VGND.n94 20.0353
R1537 VGND.n1035 VGND.n105 20.0353
R1538 VGND.n1031 VGND.n105 20.0353
R1539 VGND.n1031 VGND.n107 20.0353
R1540 VGND.n1017 VGND.n107 20.0353
R1541 VGND.n1017 VGND.n119 20.0353
R1542 VGND.n1013 VGND.n119 20.0353
R1543 VGND.n1013 VGND.n121 20.0353
R1544 VGND.n999 VGND.n121 20.0353
R1545 VGND.n999 VGND.n134 20.0353
R1546 VGND.n995 VGND.n134 20.0353
R1547 VGND.n995 VGND.n136 20.0353
R1548 VGND.n982 VGND.n136 20.0353
R1549 VGND.n982 VGND.n149 20.0353
R1550 VGND.n978 VGND.n149 20.0353
R1551 VGND.n978 VGND.n151 20.0353
R1552 VGND.n966 VGND.n151 20.0353
R1553 VGND.n966 VGND.n163 20.0353
R1554 VGND.n962 VGND.n163 20.0353
R1555 VGND.n962 VGND.n165 20.0353
R1556 VGND.n947 VGND.n165 20.0353
R1557 VGND.n947 VGND.n177 20.0353
R1558 VGND.n943 VGND.n177 20.0353
R1559 VGND.n943 VGND.n179 20.0353
R1560 VGND.n929 VGND.n179 20.0353
R1561 VGND.n929 VGND.n191 20.0353
R1562 VGND.n925 VGND.n191 20.0353
R1563 VGND.n925 VGND.n193 20.0353
R1564 VGND.n911 VGND.n193 20.0353
R1565 VGND.n911 VGND.n205 20.0353
R1566 VGND.n907 VGND.n205 20.0353
R1567 VGND.n907 VGND.n207 20.0353
R1568 VGND.n893 VGND.n207 20.0353
R1569 VGND.n893 VGND.n219 20.0353
R1570 VGND.n889 VGND.n219 20.0353
R1571 VGND.n889 VGND.n221 20.0353
R1572 VGND.n875 VGND.n221 20.0353
R1573 VGND.n875 VGND.n232 20.0353
R1574 VGND.n871 VGND.n232 20.0353
R1575 VGND.n871 VGND.n234 20.0353
R1576 VGND.n857 VGND.n234 20.0353
R1577 VGND.n857 VGND.n246 20.0353
R1578 VGND.n853 VGND.n246 20.0353
R1579 VGND.n853 VGND.n248 20.0353
R1580 VGND.n839 VGND.n248 20.0353
R1581 VGND.n839 VGND.n261 20.0353
R1582 VGND.n835 VGND.n261 20.0353
R1583 VGND.n835 VGND.n263 20.0353
R1584 VGND.n822 VGND.n263 20.0353
R1585 VGND.n822 VGND.n276 20.0353
R1586 VGND.n818 VGND.n276 20.0353
R1587 VGND.n818 VGND.n278 20.0353
R1588 VGND.n805 VGND.n278 20.0353
R1589 VGND.n805 VGND.n290 20.0353
R1590 VGND.n801 VGND.n290 20.0353
R1591 VGND.n801 VGND.n292 20.0353
R1592 VGND.n788 VGND.n292 20.0353
R1593 VGND.n788 VGND.n304 20.0353
R1594 VGND.n784 VGND.n304 20.0353
R1595 VGND.n1175 VGND.n12 18.9222
R1596 VGND.n526 VGND.n319 18.9222
R1597 VGND.n1019 VGND.t31 18.6193
R1598 VGND.n244 VGND.t63 18.6193
R1599 VGND.n48 VGND.t9 17.1298
R1600 VGND.t21 VGND.n82 17.1298
R1601 VGND.n824 VGND.t71 17.1298
R1602 VGND.n1101 VGND.t1 15.6403
R1603 VGND.n1073 VGND.t19 15.6403
R1604 VGND.t79 VGND.n280 15.6403
R1605 VGND.n110 VGND.t27 14.1508
R1606 VGND.n851 VGND.t69 14.1508
R1607 VGND.n993 VGND.t33 12.6613
R1608 VGND.t59 VGND.n216 12.6613
R1609 VGND.n175 VGND.t45 11.1718
R1610 VGND.n931 VGND.t3 11.1718
R1611 VGND.t5 VGND.n153 9.68229
R1612 VGND.n913 VGND.t53 9.68229
R1613 VGND.n780 VGND.n779 9.3005
R1614 VGND.n299 VGND.n298 9.3005
R1615 VGND.n793 VGND.n792 9.3005
R1616 VGND.n794 VGND.n297 9.3005
R1617 VGND.n797 VGND.n796 9.3005
R1618 VGND.n795 VGND.n285 9.3005
R1619 VGND.n810 VGND.n809 9.3005
R1620 VGND.n811 VGND.n283 9.3005
R1621 VGND.n814 VGND.n813 9.3005
R1622 VGND.n812 VGND.n271 9.3005
R1623 VGND.n827 VGND.n826 9.3005
R1624 VGND.n828 VGND.n268 9.3005
R1625 VGND.n831 VGND.n830 9.3005
R1626 VGND.n829 VGND.n256 9.3005
R1627 VGND.n844 VGND.n843 9.3005
R1628 VGND.n845 VGND.n253 9.3005
R1629 VGND.n849 VGND.n848 9.3005
R1630 VGND.n241 VGND.n240 9.3005
R1631 VGND.n862 VGND.n861 9.3005
R1632 VGND.n863 VGND.n239 9.3005
R1633 VGND.n867 VGND.n866 9.3005
R1634 VGND.n228 VGND.n227 9.3005
R1635 VGND.n880 VGND.n879 9.3005
R1636 VGND.n881 VGND.n226 9.3005
R1637 VGND.n885 VGND.n884 9.3005
R1638 VGND.n214 VGND.n213 9.3005
R1639 VGND.n898 VGND.n897 9.3005
R1640 VGND.n899 VGND.n212 9.3005
R1641 VGND.n903 VGND.n902 9.3005
R1642 VGND.n200 VGND.n199 9.3005
R1643 VGND.n916 VGND.n915 9.3005
R1644 VGND.n917 VGND.n198 9.3005
R1645 VGND.n921 VGND.n920 9.3005
R1646 VGND.n186 VGND.n185 9.3005
R1647 VGND.n934 VGND.n933 9.3005
R1648 VGND.n937 VGND.n184 9.3005
R1649 VGND.n939 VGND.n938 9.3005
R1650 VGND.n172 VGND.n171 9.3005
R1651 VGND.n952 VGND.n951 9.3005
R1652 VGND.n955 VGND.n170 9.3005
R1653 VGND.n958 VGND.n957 9.3005
R1654 VGND.n956 VGND.n159 9.3005
R1655 VGND.n970 VGND.n969 9.3005
R1656 VGND.n971 VGND.n156 9.3005
R1657 VGND.n974 VGND.n973 9.3005
R1658 VGND.n972 VGND.n144 9.3005
R1659 VGND.n987 VGND.n986 9.3005
R1660 VGND.n988 VGND.n141 9.3005
R1661 VGND.n991 VGND.n990 9.3005
R1662 VGND.n989 VGND.n129 9.3005
R1663 VGND.n1004 VGND.n1003 9.3005
R1664 VGND.n1005 VGND.n126 9.3005
R1665 VGND.n1009 VGND.n1008 9.3005
R1666 VGND.n114 VGND.n113 9.3005
R1667 VGND.n1022 VGND.n1021 9.3005
R1668 VGND.n1023 VGND.n112 9.3005
R1669 VGND.n1027 VGND.n1026 9.3005
R1670 VGND.n100 VGND.n99 9.3005
R1671 VGND.n1040 VGND.n1039 9.3005
R1672 VGND.n1041 VGND.n98 9.3005
R1673 VGND.n1045 VGND.n1044 9.3005
R1674 VGND.n87 VGND.n86 9.3005
R1675 VGND.n1058 VGND.n1057 9.3005
R1676 VGND.n1059 VGND.n85 9.3005
R1677 VGND.n1063 VGND.n1062 9.3005
R1678 VGND.n73 VGND.n72 9.3005
R1679 VGND.n1076 VGND.n1075 9.3005
R1680 VGND.n1077 VGND.n71 9.3005
R1681 VGND.n1081 VGND.n1080 9.3005
R1682 VGND.n59 VGND.n58 9.3005
R1683 VGND.n1094 VGND.n1093 9.3005
R1684 VGND.n1097 VGND.n57 9.3005
R1685 VGND.n1099 VGND.n1098 9.3005
R1686 VGND.n45 VGND.n44 9.3005
R1687 VGND.n1112 VGND.n1111 9.3005
R1688 VGND.n1115 VGND.n43 9.3005
R1689 VGND.n1117 VGND.n1116 9.3005
R1690 VGND.n32 VGND.n31 9.3005
R1691 VGND.n1130 VGND.n1129 9.3005
R1692 VGND.n1132 VGND.n29 9.3005
R1693 VGND.n1138 VGND.n1137 9.3005
R1694 VGND.n1136 VGND.n30 9.3005
R1695 VGND.n1135 VGND.n1134 9.3005
R1696 VGND.n1133 VGND.n4 9.3005
R1697 VGND.n1180 VGND.n1 9.3005
R1698 VGND.n313 VGND.n312 9.3005
R1699 VGND.n771 VGND.n770 9.3005
R1700 VGND.n769 VGND.n315 9.3005
R1701 VGND.n768 VGND.n767 9.3005
R1702 VGND.n317 VGND.n316 9.3005
R1703 VGND.n761 VGND.n760 9.3005
R1704 VGND.n1174 VGND.n1173 9.3005
R1705 VGND.n1172 VGND.n14 9.3005
R1706 VGND.n1171 VGND.n1170 9.3005
R1707 VGND.n1169 VGND.n1155 9.3005
R1708 VGND.n1168 VGND.n1167 9.3005
R1709 VGND.n1166 VGND.n0 9.3005
R1710 VGND.n527 VGND.n526 9.3005
R1711 VGND.n525 VGND.n320 9.3005
R1712 VGND.n524 VGND.n523 9.3005
R1713 VGND.n522 VGND.n323 9.3005
R1714 VGND.n521 VGND.n520 9.3005
R1715 VGND.n519 VGND.n324 9.3005
R1716 VGND.n518 VGND.n517 9.3005
R1717 VGND.n516 VGND.n327 9.3005
R1718 VGND.n515 VGND.n514 9.3005
R1719 VGND.n513 VGND.n328 9.3005
R1720 VGND.n512 VGND.n511 9.3005
R1721 VGND.n510 VGND.n331 9.3005
R1722 VGND.n509 VGND.n508 9.3005
R1723 VGND.n507 VGND.n332 9.3005
R1724 VGND.n506 VGND.n505 9.3005
R1725 VGND.n504 VGND.n336 9.3005
R1726 VGND.n503 VGND.n502 9.3005
R1727 VGND.n501 VGND.n337 9.3005
R1728 VGND.n500 VGND.n499 9.3005
R1729 VGND.n498 VGND.n340 9.3005
R1730 VGND.n497 VGND.n496 9.3005
R1731 VGND.n495 VGND.n341 9.3005
R1732 VGND.n494 VGND.n493 9.3005
R1733 VGND.n492 VGND.n344 9.3005
R1734 VGND.n491 VGND.n490 9.3005
R1735 VGND.n489 VGND.n345 9.3005
R1736 VGND.n488 VGND.n487 9.3005
R1737 VGND.n486 VGND.n348 9.3005
R1738 VGND.n485 VGND.n484 9.3005
R1739 VGND.n483 VGND.n349 9.3005
R1740 VGND.n482 VGND.n481 9.3005
R1741 VGND.n480 VGND.n353 9.3005
R1742 VGND.n479 VGND.n478 9.3005
R1743 VGND.n477 VGND.n354 9.3005
R1744 VGND.n476 VGND.n475 9.3005
R1745 VGND.n474 VGND.n357 9.3005
R1746 VGND.n473 VGND.n472 9.3005
R1747 VGND.n471 VGND.n358 9.3005
R1748 VGND.n470 VGND.n469 9.3005
R1749 VGND.n468 VGND.n361 9.3005
R1750 VGND.n467 VGND.n466 9.3005
R1751 VGND.n465 VGND.n362 9.3005
R1752 VGND.n464 VGND.n463 9.3005
R1753 VGND.n462 VGND.n365 9.3005
R1754 VGND.n461 VGND.n460 9.3005
R1755 VGND.n459 VGND.n366 9.3005
R1756 VGND.n458 VGND.n457 9.3005
R1757 VGND.n456 VGND.n369 9.3005
R1758 VGND.n455 VGND.n454 9.3005
R1759 VGND.n453 VGND.n370 9.3005
R1760 VGND.n452 VGND.n451 9.3005
R1761 VGND.n450 VGND.n374 9.3005
R1762 VGND.n449 VGND.n448 9.3005
R1763 VGND.n447 VGND.n375 9.3005
R1764 VGND.n446 VGND.n445 9.3005
R1765 VGND.n444 VGND.n378 9.3005
R1766 VGND.n443 VGND.n442 9.3005
R1767 VGND.n441 VGND.n379 9.3005
R1768 VGND.n440 VGND.n439 9.3005
R1769 VGND.n438 VGND.n382 9.3005
R1770 VGND.n437 VGND.n436 9.3005
R1771 VGND.n435 VGND.n383 9.3005
R1772 VGND.n434 VGND.n433 9.3005
R1773 VGND.n432 VGND.n386 9.3005
R1774 VGND.n431 VGND.n430 9.3005
R1775 VGND.n429 VGND.n387 9.3005
R1776 VGND.n428 VGND.n427 9.3005
R1777 VGND.n426 VGND.n390 9.3005
R1778 VGND.n425 VGND.n424 9.3005
R1779 VGND.n423 VGND.n391 9.3005
R1780 VGND.n422 VGND.n421 9.3005
R1781 VGND.n420 VGND.n395 9.3005
R1782 VGND.n419 VGND.n418 9.3005
R1783 VGND.n417 VGND.n396 9.3005
R1784 VGND.n416 VGND.n415 9.3005
R1785 VGND.n414 VGND.n399 9.3005
R1786 VGND.n413 VGND.n412 9.3005
R1787 VGND.n411 VGND.n400 9.3005
R1788 VGND.n410 VGND.n409 9.3005
R1789 VGND.n408 VGND.n403 9.3005
R1790 VGND.n407 VGND.n406 9.3005
R1791 VGND.n405 VGND.n404 9.3005
R1792 VGND.n16 VGND.n15 9.3005
R1793 VGND.n1153 VGND.n1152 9.3005
R1794 VGND.n1154 VGND.n12 9.3005
R1795 VGND.n758 VGND.n757 9.3005
R1796 VGND.n529 VGND.n528 9.3005
R1797 VGND.n752 VGND.n751 9.3005
R1798 VGND.n750 VGND.n531 9.3005
R1799 VGND.n749 VGND.n748 9.3005
R1800 VGND.n533 VGND.n532 9.3005
R1801 VGND.n742 VGND.n741 9.3005
R1802 VGND.n740 VGND.n535 9.3005
R1803 VGND.n739 VGND.n738 9.3005
R1804 VGND.n537 VGND.n536 9.3005
R1805 VGND.n732 VGND.n731 9.3005
R1806 VGND.n730 VGND.n539 9.3005
R1807 VGND.n729 VGND.n728 9.3005
R1808 VGND.n541 VGND.n540 9.3005
R1809 VGND.n722 VGND.n721 9.3005
R1810 VGND.n720 VGND.n543 9.3005
R1811 VGND.n719 VGND.n718 9.3005
R1812 VGND.n545 VGND.n544 9.3005
R1813 VGND.n712 VGND.n711 9.3005
R1814 VGND.n710 VGND.n547 9.3005
R1815 VGND.n709 VGND.n708 9.3005
R1816 VGND.n549 VGND.n548 9.3005
R1817 VGND.n702 VGND.n701 9.3005
R1818 VGND.n700 VGND.n551 9.3005
R1819 VGND.n699 VGND.n698 9.3005
R1820 VGND.n553 VGND.n552 9.3005
R1821 VGND.n693 VGND.n692 9.3005
R1822 VGND.n691 VGND.n555 9.3005
R1823 VGND.n690 VGND.n689 9.3005
R1824 VGND.n557 VGND.n556 9.3005
R1825 VGND.n683 VGND.n682 9.3005
R1826 VGND.n681 VGND.n559 9.3005
R1827 VGND.n680 VGND.n679 9.3005
R1828 VGND.n561 VGND.n560 9.3005
R1829 VGND.n673 VGND.n672 9.3005
R1830 VGND.n671 VGND.n563 9.3005
R1831 VGND.n670 VGND.n669 9.3005
R1832 VGND.n565 VGND.n564 9.3005
R1833 VGND.n664 VGND.n663 9.3005
R1834 VGND.n662 VGND.n567 9.3005
R1835 VGND.n661 VGND.n660 9.3005
R1836 VGND.n569 VGND.n568 9.3005
R1837 VGND.n654 VGND.n653 9.3005
R1838 VGND.n652 VGND.n571 9.3005
R1839 VGND.n651 VGND.n650 9.3005
R1840 VGND.n573 VGND.n572 9.3005
R1841 VGND.n645 VGND.n644 9.3005
R1842 VGND.n643 VGND.n575 9.3005
R1843 VGND.n642 VGND.n641 9.3005
R1844 VGND.n577 VGND.n576 9.3005
R1845 VGND.n635 VGND.n634 9.3005
R1846 VGND.n633 VGND.n579 9.3005
R1847 VGND.n632 VGND.n631 9.3005
R1848 VGND.n581 VGND.n580 9.3005
R1849 VGND.n625 VGND.n624 9.3005
R1850 VGND.n623 VGND.n583 9.3005
R1851 VGND.n622 VGND.n621 9.3005
R1852 VGND.n585 VGND.n584 9.3005
R1853 VGND.n616 VGND.n615 9.3005
R1854 VGND.n614 VGND.n587 9.3005
R1855 VGND.n613 VGND.n612 9.3005
R1856 VGND.n589 VGND.n588 9.3005
R1857 VGND.n607 VGND.n606 9.3005
R1858 VGND.n605 VGND.n592 9.3005
R1859 VGND.n604 VGND.n603 9.3005
R1860 VGND.n594 VGND.n593 9.3005
R1861 VGND.n597 VGND.n596 9.3005
R1862 VGND.n306 VGND.n305 9.3005
R1863 VGND.n1147 VGND.n1145 9.3005
R1864 VGND.n1144 VGND.n21 9.3005
R1865 VGND.n1143 VGND.n1142 9.3005
R1866 VGND.n23 VGND.n22 9.3005
R1867 VGND.n1125 VGND.n1124 9.3005
R1868 VGND.n1123 VGND.n36 9.3005
R1869 VGND.n1122 VGND.n1121 9.3005
R1870 VGND.n38 VGND.n37 9.3005
R1871 VGND.n1107 VGND.n1106 9.3005
R1872 VGND.n1105 VGND.n50 9.3005
R1873 VGND.n1104 VGND.n1103 9.3005
R1874 VGND.n52 VGND.n51 9.3005
R1875 VGND.n1089 VGND.n1088 9.3005
R1876 VGND.n1087 VGND.n64 9.3005
R1877 VGND.n1086 VGND.n1085 9.3005
R1878 VGND.n66 VGND.n65 9.3005
R1879 VGND.n1071 VGND.n1070 9.3005
R1880 VGND.n1069 VGND.n78 9.3005
R1881 VGND.n1068 VGND.n1067 9.3005
R1882 VGND.n80 VGND.n79 9.3005
R1883 VGND.n1053 VGND.n1052 9.3005
R1884 VGND.n1051 VGND.n92 9.3005
R1885 VGND.n1050 VGND.n1049 9.3005
R1886 VGND.n94 VGND.n93 9.3005
R1887 VGND.n1035 VGND.n1034 9.3005
R1888 VGND.n1033 VGND.n105 9.3005
R1889 VGND.n1032 VGND.n1031 9.3005
R1890 VGND.n107 VGND.n106 9.3005
R1891 VGND.n1017 VGND.n1016 9.3005
R1892 VGND.n1015 VGND.n119 9.3005
R1893 VGND.n1014 VGND.n1013 9.3005
R1894 VGND.n121 VGND.n120 9.3005
R1895 VGND.n999 VGND.n998 9.3005
R1896 VGND.n997 VGND.n134 9.3005
R1897 VGND.n996 VGND.n995 9.3005
R1898 VGND.n136 VGND.n135 9.3005
R1899 VGND.n982 VGND.n981 9.3005
R1900 VGND.n980 VGND.n149 9.3005
R1901 VGND.n979 VGND.n978 9.3005
R1902 VGND.n151 VGND.n150 9.3005
R1903 VGND.n966 VGND.n965 9.3005
R1904 VGND.n964 VGND.n163 9.3005
R1905 VGND.n963 VGND.n962 9.3005
R1906 VGND.n165 VGND.n164 9.3005
R1907 VGND.n947 VGND.n946 9.3005
R1908 VGND.n945 VGND.n177 9.3005
R1909 VGND.n944 VGND.n943 9.3005
R1910 VGND.n179 VGND.n178 9.3005
R1911 VGND.n929 VGND.n928 9.3005
R1912 VGND.n927 VGND.n191 9.3005
R1913 VGND.n926 VGND.n925 9.3005
R1914 VGND.n193 VGND.n192 9.3005
R1915 VGND.n911 VGND.n910 9.3005
R1916 VGND.n909 VGND.n205 9.3005
R1917 VGND.n908 VGND.n907 9.3005
R1918 VGND.n207 VGND.n206 9.3005
R1919 VGND.n893 VGND.n892 9.3005
R1920 VGND.n891 VGND.n219 9.3005
R1921 VGND.n890 VGND.n889 9.3005
R1922 VGND.n221 VGND.n220 9.3005
R1923 VGND.n875 VGND.n874 9.3005
R1924 VGND.n873 VGND.n232 9.3005
R1925 VGND.n872 VGND.n871 9.3005
R1926 VGND.n234 VGND.n233 9.3005
R1927 VGND.n857 VGND.n856 9.3005
R1928 VGND.n855 VGND.n246 9.3005
R1929 VGND.n854 VGND.n853 9.3005
R1930 VGND.n248 VGND.n247 9.3005
R1931 VGND.n839 VGND.n838 9.3005
R1932 VGND.n837 VGND.n261 9.3005
R1933 VGND.n836 VGND.n835 9.3005
R1934 VGND.n263 VGND.n262 9.3005
R1935 VGND.n822 VGND.n821 9.3005
R1936 VGND.n820 VGND.n276 9.3005
R1937 VGND.n819 VGND.n818 9.3005
R1938 VGND.n278 VGND.n277 9.3005
R1939 VGND.n805 VGND.n804 9.3005
R1940 VGND.n803 VGND.n290 9.3005
R1941 VGND.n802 VGND.n801 9.3005
R1942 VGND.n292 VGND.n291 9.3005
R1943 VGND.n788 VGND.n787 9.3005
R1944 VGND.n786 VGND.n304 9.3005
R1945 VGND.n785 VGND.n784 9.3005
R1946 VGND.n1011 VGND.t35 8.19278
R1947 VGND.n237 VGND.t67 8.19278
R1948 VGND.n41 VGND.t7 6.70328
R1949 VGND.t23 VGND.n89 6.70328
R1950 VGND.n833 VGND.t75 6.70328
R1951 VGND.n1091 VGND.t13 5.21377
R1952 VGND.n1083 VGND.t15 5.21377
R1953 VGND.n1176 VGND.n11 4.90034
R1954 VGND.n1182 VGND.n2 4.82369
R1955 VGND.n777 VGND.n311 4.82369
R1956 VGND.n777 VGND.n776 4.82369
R1957 VGND.n1182 VGND.n1181 4.82369
R1958 VGND.n1146 VGND.n11 4.79939
R1959 VGND.n103 VGND.t25 3.72426
R1960 VGND.n841 VGND.t73 3.72426
R1961 VGND.n1145 VGND.n11 2.47089
R1962 VGND.n1183 VGND.n1182 2.23966
R1963 VGND.n778 VGND.n777 2.23966
R1964 VGND.n1001 VGND.t37 2.23476
R1965 VGND.t65 VGND.n223 2.23476
R1966 VGND.n168 VGND.t43 0.745253
R1967 VGND.n923 VGND.t51 0.745253
R1968 VGND.n785 VGND.n305 0.476043
R1969 VGND.n1173 VGND.n1154 0.424413
R1970 VGND.n759 VGND.n758 0.291261
R1971 VGND.n760 VGND.n759 0.23963
R1972 VGND.n1145 VGND.n1144 0.196152
R1973 VGND.n1144 VGND.n1143 0.196152
R1974 VGND.n1143 VGND.n22 0.196152
R1975 VGND.n1124 VGND.n22 0.196152
R1976 VGND.n1124 VGND.n1123 0.196152
R1977 VGND.n1123 VGND.n1122 0.196152
R1978 VGND.n1122 VGND.n37 0.196152
R1979 VGND.n1106 VGND.n37 0.196152
R1980 VGND.n1106 VGND.n1105 0.196152
R1981 VGND.n1105 VGND.n1104 0.196152
R1982 VGND.n1104 VGND.n51 0.196152
R1983 VGND.n1088 VGND.n51 0.196152
R1984 VGND.n1088 VGND.n1087 0.196152
R1985 VGND.n1087 VGND.n1086 0.196152
R1986 VGND.n1086 VGND.n65 0.196152
R1987 VGND.n1070 VGND.n65 0.196152
R1988 VGND.n1070 VGND.n1069 0.196152
R1989 VGND.n1069 VGND.n1068 0.196152
R1990 VGND.n1068 VGND.n79 0.196152
R1991 VGND.n1052 VGND.n79 0.196152
R1992 VGND.n1052 VGND.n1051 0.196152
R1993 VGND.n1051 VGND.n1050 0.196152
R1994 VGND.n1050 VGND.n93 0.196152
R1995 VGND.n1034 VGND.n93 0.196152
R1996 VGND.n1034 VGND.n1033 0.196152
R1997 VGND.n1033 VGND.n1032 0.196152
R1998 VGND.n1032 VGND.n106 0.196152
R1999 VGND.n1016 VGND.n106 0.196152
R2000 VGND.n1016 VGND.n1015 0.196152
R2001 VGND.n1015 VGND.n1014 0.196152
R2002 VGND.n1014 VGND.n120 0.196152
R2003 VGND.n998 VGND.n120 0.196152
R2004 VGND.n998 VGND.n997 0.196152
R2005 VGND.n997 VGND.n996 0.196152
R2006 VGND.n996 VGND.n135 0.196152
R2007 VGND.n981 VGND.n135 0.196152
R2008 VGND.n981 VGND.n980 0.196152
R2009 VGND.n980 VGND.n979 0.196152
R2010 VGND.n979 VGND.n150 0.196152
R2011 VGND.n965 VGND.n150 0.196152
R2012 VGND.n965 VGND.n964 0.196152
R2013 VGND.n964 VGND.n963 0.196152
R2014 VGND.n963 VGND.n164 0.196152
R2015 VGND.n946 VGND.n164 0.196152
R2016 VGND.n946 VGND.n945 0.196152
R2017 VGND.n945 VGND.n944 0.196152
R2018 VGND.n944 VGND.n178 0.196152
R2019 VGND.n928 VGND.n178 0.196152
R2020 VGND.n928 VGND.n927 0.196152
R2021 VGND.n927 VGND.n926 0.196152
R2022 VGND.n926 VGND.n192 0.196152
R2023 VGND.n910 VGND.n192 0.196152
R2024 VGND.n910 VGND.n909 0.196152
R2025 VGND.n909 VGND.n908 0.196152
R2026 VGND.n908 VGND.n206 0.196152
R2027 VGND.n892 VGND.n206 0.196152
R2028 VGND.n892 VGND.n891 0.196152
R2029 VGND.n891 VGND.n890 0.196152
R2030 VGND.n890 VGND.n220 0.196152
R2031 VGND.n874 VGND.n220 0.196152
R2032 VGND.n874 VGND.n873 0.196152
R2033 VGND.n873 VGND.n872 0.196152
R2034 VGND.n872 VGND.n233 0.196152
R2035 VGND.n856 VGND.n233 0.196152
R2036 VGND.n856 VGND.n855 0.196152
R2037 VGND.n855 VGND.n854 0.196152
R2038 VGND.n854 VGND.n247 0.196152
R2039 VGND.n838 VGND.n247 0.196152
R2040 VGND.n838 VGND.n837 0.196152
R2041 VGND.n837 VGND.n836 0.196152
R2042 VGND.n836 VGND.n262 0.196152
R2043 VGND.n821 VGND.n262 0.196152
R2044 VGND.n821 VGND.n820 0.196152
R2045 VGND.n820 VGND.n819 0.196152
R2046 VGND.n819 VGND.n277 0.196152
R2047 VGND.n804 VGND.n277 0.196152
R2048 VGND.n804 VGND.n803 0.196152
R2049 VGND.n803 VGND.n802 0.196152
R2050 VGND.n802 VGND.n291 0.196152
R2051 VGND.n787 VGND.n291 0.196152
R2052 VGND.n787 VGND.n786 0.196152
R2053 VGND.n786 VGND.n785 0.196152
R2054 VGND.n758 VGND.n528 0.196152
R2055 VGND.n751 VGND.n528 0.196152
R2056 VGND.n751 VGND.n750 0.196152
R2057 VGND.n750 VGND.n749 0.196152
R2058 VGND.n749 VGND.n532 0.196152
R2059 VGND.n741 VGND.n532 0.196152
R2060 VGND.n741 VGND.n740 0.196152
R2061 VGND.n740 VGND.n739 0.196152
R2062 VGND.n739 VGND.n536 0.196152
R2063 VGND.n731 VGND.n536 0.196152
R2064 VGND.n731 VGND.n730 0.196152
R2065 VGND.n730 VGND.n729 0.196152
R2066 VGND.n729 VGND.n540 0.196152
R2067 VGND.n721 VGND.n540 0.196152
R2068 VGND.n721 VGND.n720 0.196152
R2069 VGND.n720 VGND.n719 0.196152
R2070 VGND.n719 VGND.n544 0.196152
R2071 VGND.n711 VGND.n544 0.196152
R2072 VGND.n711 VGND.n710 0.196152
R2073 VGND.n710 VGND.n709 0.196152
R2074 VGND.n709 VGND.n548 0.196152
R2075 VGND.n701 VGND.n548 0.196152
R2076 VGND.n701 VGND.n700 0.196152
R2077 VGND.n700 VGND.n699 0.196152
R2078 VGND.n699 VGND.n552 0.196152
R2079 VGND.n692 VGND.n552 0.196152
R2080 VGND.n692 VGND.n691 0.196152
R2081 VGND.n691 VGND.n690 0.196152
R2082 VGND.n690 VGND.n556 0.196152
R2083 VGND.n682 VGND.n556 0.196152
R2084 VGND.n682 VGND.n681 0.196152
R2085 VGND.n681 VGND.n680 0.196152
R2086 VGND.n680 VGND.n560 0.196152
R2087 VGND.n672 VGND.n560 0.196152
R2088 VGND.n672 VGND.n671 0.196152
R2089 VGND.n671 VGND.n670 0.196152
R2090 VGND.n670 VGND.n564 0.196152
R2091 VGND.n663 VGND.n564 0.196152
R2092 VGND.n663 VGND.n662 0.196152
R2093 VGND.n662 VGND.n661 0.196152
R2094 VGND.n661 VGND.n568 0.196152
R2095 VGND.n653 VGND.n568 0.196152
R2096 VGND.n653 VGND.n652 0.196152
R2097 VGND.n652 VGND.n651 0.196152
R2098 VGND.n651 VGND.n572 0.196152
R2099 VGND.n644 VGND.n572 0.196152
R2100 VGND.n644 VGND.n643 0.196152
R2101 VGND.n643 VGND.n642 0.196152
R2102 VGND.n642 VGND.n576 0.196152
R2103 VGND.n634 VGND.n576 0.196152
R2104 VGND.n634 VGND.n633 0.196152
R2105 VGND.n633 VGND.n632 0.196152
R2106 VGND.n632 VGND.n580 0.196152
R2107 VGND.n624 VGND.n580 0.196152
R2108 VGND.n624 VGND.n623 0.196152
R2109 VGND.n623 VGND.n622 0.196152
R2110 VGND.n622 VGND.n584 0.196152
R2111 VGND.n615 VGND.n584 0.196152
R2112 VGND.n615 VGND.n614 0.196152
R2113 VGND.n614 VGND.n613 0.196152
R2114 VGND.n613 VGND.n588 0.196152
R2115 VGND.n606 VGND.n588 0.196152
R2116 VGND.n606 VGND.n605 0.196152
R2117 VGND.n605 VGND.n604 0.196152
R2118 VGND.n604 VGND.n593 0.196152
R2119 VGND.n596 VGND.n593 0.196152
R2120 VGND.n596 VGND.n305 0.196152
R2121 VGND.n1154 VGND.n1153 0.196152
R2122 VGND.n1153 VGND.n15 0.196152
R2123 VGND.n404 VGND.n15 0.196152
R2124 VGND.n407 VGND.n404 0.196152
R2125 VGND.n408 VGND.n407 0.196152
R2126 VGND.n409 VGND.n408 0.196152
R2127 VGND.n409 VGND.n400 0.196152
R2128 VGND.n413 VGND.n400 0.196152
R2129 VGND.n414 VGND.n413 0.196152
R2130 VGND.n415 VGND.n414 0.196152
R2131 VGND.n415 VGND.n396 0.196152
R2132 VGND.n419 VGND.n396 0.196152
R2133 VGND.n420 VGND.n419 0.196152
R2134 VGND.n421 VGND.n420 0.196152
R2135 VGND.n421 VGND.n391 0.196152
R2136 VGND.n425 VGND.n391 0.196152
R2137 VGND.n426 VGND.n425 0.196152
R2138 VGND.n427 VGND.n426 0.196152
R2139 VGND.n427 VGND.n387 0.196152
R2140 VGND.n431 VGND.n387 0.196152
R2141 VGND.n432 VGND.n431 0.196152
R2142 VGND.n433 VGND.n432 0.196152
R2143 VGND.n433 VGND.n383 0.196152
R2144 VGND.n437 VGND.n383 0.196152
R2145 VGND.n438 VGND.n437 0.196152
R2146 VGND.n439 VGND.n438 0.196152
R2147 VGND.n439 VGND.n379 0.196152
R2148 VGND.n443 VGND.n379 0.196152
R2149 VGND.n444 VGND.n443 0.196152
R2150 VGND.n445 VGND.n444 0.196152
R2151 VGND.n445 VGND.n375 0.196152
R2152 VGND.n449 VGND.n375 0.196152
R2153 VGND.n450 VGND.n449 0.196152
R2154 VGND.n451 VGND.n450 0.196152
R2155 VGND.n451 VGND.n370 0.196152
R2156 VGND.n455 VGND.n370 0.196152
R2157 VGND.n456 VGND.n455 0.196152
R2158 VGND.n457 VGND.n456 0.196152
R2159 VGND.n457 VGND.n366 0.196152
R2160 VGND.n461 VGND.n366 0.196152
R2161 VGND.n462 VGND.n461 0.196152
R2162 VGND.n463 VGND.n462 0.196152
R2163 VGND.n463 VGND.n362 0.196152
R2164 VGND.n467 VGND.n362 0.196152
R2165 VGND.n468 VGND.n467 0.196152
R2166 VGND.n469 VGND.n468 0.196152
R2167 VGND.n469 VGND.n358 0.196152
R2168 VGND.n473 VGND.n358 0.196152
R2169 VGND.n474 VGND.n473 0.196152
R2170 VGND.n475 VGND.n474 0.196152
R2171 VGND.n475 VGND.n354 0.196152
R2172 VGND.n479 VGND.n354 0.196152
R2173 VGND.n480 VGND.n479 0.196152
R2174 VGND.n481 VGND.n480 0.196152
R2175 VGND.n481 VGND.n349 0.196152
R2176 VGND.n485 VGND.n349 0.196152
R2177 VGND.n486 VGND.n485 0.196152
R2178 VGND.n487 VGND.n486 0.196152
R2179 VGND.n487 VGND.n345 0.196152
R2180 VGND.n491 VGND.n345 0.196152
R2181 VGND.n492 VGND.n491 0.196152
R2182 VGND.n493 VGND.n492 0.196152
R2183 VGND.n493 VGND.n341 0.196152
R2184 VGND.n497 VGND.n341 0.196152
R2185 VGND.n498 VGND.n497 0.196152
R2186 VGND.n499 VGND.n498 0.196152
R2187 VGND.n499 VGND.n337 0.196152
R2188 VGND.n503 VGND.n337 0.196152
R2189 VGND.n504 VGND.n503 0.196152
R2190 VGND.n505 VGND.n504 0.196152
R2191 VGND.n505 VGND.n332 0.196152
R2192 VGND.n509 VGND.n332 0.196152
R2193 VGND.n510 VGND.n509 0.196152
R2194 VGND.n511 VGND.n510 0.196152
R2195 VGND.n511 VGND.n328 0.196152
R2196 VGND.n515 VGND.n328 0.196152
R2197 VGND.n516 VGND.n515 0.196152
R2198 VGND.n517 VGND.n516 0.196152
R2199 VGND.n517 VGND.n324 0.196152
R2200 VGND.n521 VGND.n324 0.196152
R2201 VGND.n522 VGND.n521 0.196152
R2202 VGND.n523 VGND.n522 0.196152
R2203 VGND.n523 VGND.n320 0.196152
R2204 VGND.n527 VGND.n320 0.196152
R2205 VGND.n1167 VGND.n0 0.196152
R2206 VGND.n1167 VGND.n1155 0.196152
R2207 VGND.n1171 VGND.n1155 0.196152
R2208 VGND.n1172 VGND.n1171 0.196152
R2209 VGND.n1173 VGND.n1172 0.196152
R2210 VGND.n770 VGND.n312 0.196152
R2211 VGND.n770 VGND.n769 0.196152
R2212 VGND.n769 VGND.n768 0.196152
R2213 VGND.n768 VGND.n316 0.196152
R2214 VGND.n760 VGND.n316 0.196152
R2215 VGND.n759 VGND.n527 0.185283
R2216 VGND.n1183 VGND.n0 0.0874565
R2217 VGND.n778 VGND.n312 0.0874565
R2218 VGND.n1133 VGND.n1 0.0370854
R2219 VGND.n1135 VGND.n1133 0.0370854
R2220 VGND.n1136 VGND.n1135 0.0370854
R2221 VGND.n1137 VGND.n1136 0.0370854
R2222 VGND.n1137 VGND.n1132 0.0370854
R2223 VGND.n1130 VGND.n31 0.0370854
R2224 VGND.n1116 VGND.n31 0.0370854
R2225 VGND.n1116 VGND.n1115 0.0370854
R2226 VGND.n1112 VGND.n44 0.0370854
R2227 VGND.n1098 VGND.n44 0.0370854
R2228 VGND.n1098 VGND.n1097 0.0370854
R2229 VGND.n1094 VGND.n58 0.0370854
R2230 VGND.n1080 VGND.n58 0.0370854
R2231 VGND.n1077 VGND.n1076 0.0370854
R2232 VGND.n1076 VGND.n72 0.0370854
R2233 VGND.n1062 VGND.n72 0.0370854
R2234 VGND.n1059 VGND.n1058 0.0370854
R2235 VGND.n1058 VGND.n86 0.0370854
R2236 VGND.n1044 VGND.n86 0.0370854
R2237 VGND.n1041 VGND.n1040 0.0370854
R2238 VGND.n1040 VGND.n99 0.0370854
R2239 VGND.n1026 VGND.n1023 0.0370854
R2240 VGND.n1023 VGND.n1022 0.0370854
R2241 VGND.n1022 VGND.n113 0.0370854
R2242 VGND.n1008 VGND.n1005 0.0370854
R2243 VGND.n1005 VGND.n1004 0.0370854
R2244 VGND.n990 VGND.n989 0.0370854
R2245 VGND.n990 VGND.n988 0.0370854
R2246 VGND.n988 VGND.n987 0.0370854
R2247 VGND.n973 VGND.n972 0.0370854
R2248 VGND.n973 VGND.n971 0.0370854
R2249 VGND.n971 VGND.n970 0.0370854
R2250 VGND.n957 VGND.n956 0.0370854
R2251 VGND.n957 VGND.n955 0.0370854
R2252 VGND.n952 VGND.n171 0.0370854
R2253 VGND.n938 VGND.n171 0.0370854
R2254 VGND.n938 VGND.n937 0.0370854
R2255 VGND.n934 VGND.n185 0.0370854
R2256 VGND.n920 VGND.n185 0.0370854
R2257 VGND.n917 VGND.n916 0.0370854
R2258 VGND.n916 VGND.n199 0.0370854
R2259 VGND.n902 VGND.n199 0.0370854
R2260 VGND.n899 VGND.n898 0.0370854
R2261 VGND.n898 VGND.n213 0.0370854
R2262 VGND.n884 VGND.n213 0.0370854
R2263 VGND.n881 VGND.n880 0.0370854
R2264 VGND.n880 VGND.n227 0.0370854
R2265 VGND.n866 VGND.n863 0.0370854
R2266 VGND.n863 VGND.n862 0.0370854
R2267 VGND.n862 VGND.n240 0.0370854
R2268 VGND.n848 VGND.n845 0.0370854
R2269 VGND.n845 VGND.n844 0.0370854
R2270 VGND.n830 VGND.n829 0.0370854
R2271 VGND.n830 VGND.n828 0.0370854
R2272 VGND.n828 VGND.n827 0.0370854
R2273 VGND.n813 VGND.n812 0.0370854
R2274 VGND.n813 VGND.n811 0.0370854
R2275 VGND.n811 VGND.n810 0.0370854
R2276 VGND.n796 VGND.n795 0.0370854
R2277 VGND.n796 VGND.n794 0.0370854
R2278 VGND.n794 VGND.n793 0.0370854
R2279 VGND.n793 VGND.n298 0.0370854
R2280 VGND.n779 VGND.n298 0.0370854
R2281 VGND.n1132 VGND.n1131 0.0360691
R2282 VGND.n1043 VGND.n1041 0.0360691
R2283 VGND.n844 VGND.n255 0.0360691
R2284 VGND.n1183 VGND.n1 0.0350528
R2285 VGND.n779 VGND.n778 0.0350528
R2286 VGND.n956 VGND.n158 0.0340366
R2287 VGND.n920 VGND.n919 0.0340366
R2288 VGND.n1004 VGND.n128 0.0314959
R2289 VGND.n883 VGND.n881 0.0314959
R2290 VGND.n1096 VGND.n1094 0.0309878
R2291 VGND.n795 VGND.n284 0.0299715
R2292 VGND.n1080 VGND.n1079 0.0294634
R2293 VGND.n1008 VGND.n1007 0.027939
R2294 VGND VGND.n1183 0.027812
R2295 VGND.n865 VGND.n227 0.0274309
R2296 VGND.n955 VGND.n954 0.0259065
R2297 VGND.n936 VGND.n934 0.0259065
R2298 VGND.n848 VGND.n847 0.0243821
R2299 VGND.n1025 VGND.n99 0.023874
R2300 VGND.n827 VGND.n270 0.0223496
R2301 VGND.n1061 VGND.n1059 0.0213333
R2302 VGND.n1115 VGND.n1114 0.0208252
R2303 VGND.n972 VGND.n143 0.0198089
R2304 VGND.n902 VGND.n901 0.0198089
R2305 VGND.n987 VGND.n143 0.0177764
R2306 VGND.n901 VGND.n899 0.0177764
R2307 VGND.n1114 VGND.n1112 0.0167602
R2308 VGND.n1062 VGND.n1061 0.016252
R2309 VGND.n812 VGND.n270 0.0152358
R2310 VGND.n1026 VGND.n1025 0.0137114
R2311 VGND.n847 VGND.n240 0.0132033
R2312 VGND.n954 VGND.n952 0.0116789
R2313 VGND.n937 VGND.n936 0.0116789
R2314 VGND.n866 VGND.n865 0.0101545
R2315 VGND.n1007 VGND.n113 0.00964634
R2316 VGND.n1079 VGND.n1077 0.00812195
R2317 VGND.n810 VGND.n284 0.00761382
R2318 VGND.n1097 VGND.n1096 0.00659756
R2319 VGND.n989 VGND.n128 0.00608943
R2320 VGND.n884 VGND.n883 0.00608943
R2321 VGND.n970 VGND.n158 0.00354878
R2322 VGND.n919 VGND.n917 0.00354878
R2323 VGND.n1131 VGND.n1130 0.00151626
R2324 VGND.n1044 VGND.n1043 0.00151626
R2325 VGND.n829 VGND.n255 0.00151626
R2326 a_118_844.n39 a_118_844.n38 103.645
R2327 a_118_844.n38 a_118_844.n37 103.526
R2328 a_118_844.n36 a_118_844.n35 103.526
R2329 a_118_844.n34 a_118_844.n33 103.526
R2330 a_118_844.n32 a_118_844.n31 103.526
R2331 a_118_844.n30 a_118_844.n29 103.526
R2332 a_118_844.n28 a_118_844.n27 103.526
R2333 a_118_844.n26 a_118_844.n25 103.526
R2334 a_118_844.n24 a_118_844.n23 103.526
R2335 a_118_844.n22 a_118_844.n21 103.526
R2336 a_118_844.n20 a_118_844.n19 103.526
R2337 a_118_844.n18 a_118_844.n17 103.526
R2338 a_118_844.n16 a_118_844.n15 103.526
R2339 a_118_844.n14 a_118_844.n13 103.526
R2340 a_118_844.n12 a_118_844.n11 103.526
R2341 a_118_844.n10 a_118_844.n9 103.526
R2342 a_118_844.n8 a_118_844.n7 103.526
R2343 a_118_844.n6 a_118_844.n5 103.526
R2344 a_118_844.n4 a_118_844.n3 103.526
R2345 a_118_844.n2 a_118_844.n1 103.526
R2346 a_118_844.n39 a_118_844.t39 30.0005
R2347 a_118_844.t40 a_118_844.n39 30.0005
R2348 a_118_844.n37 a_118_844.t37 30.0005
R2349 a_118_844.n37 a_118_844.t38 30.0005
R2350 a_118_844.n35 a_118_844.t35 30.0005
R2351 a_118_844.n35 a_118_844.t36 30.0005
R2352 a_118_844.n33 a_118_844.t33 30.0005
R2353 a_118_844.n33 a_118_844.t34 30.0005
R2354 a_118_844.n31 a_118_844.t31 30.0005
R2355 a_118_844.n31 a_118_844.t32 30.0005
R2356 a_118_844.n29 a_118_844.t29 30.0005
R2357 a_118_844.n29 a_118_844.t30 30.0005
R2358 a_118_844.n27 a_118_844.t27 30.0005
R2359 a_118_844.n27 a_118_844.t28 30.0005
R2360 a_118_844.n25 a_118_844.t25 30.0005
R2361 a_118_844.n25 a_118_844.t26 30.0005
R2362 a_118_844.n23 a_118_844.t23 30.0005
R2363 a_118_844.n23 a_118_844.t24 30.0005
R2364 a_118_844.n21 a_118_844.t21 30.0005
R2365 a_118_844.n21 a_118_844.t22 30.0005
R2366 a_118_844.n19 a_118_844.t19 30.0005
R2367 a_118_844.n19 a_118_844.t20 30.0005
R2368 a_118_844.n17 a_118_844.t17 30.0005
R2369 a_118_844.n17 a_118_844.t18 30.0005
R2370 a_118_844.n15 a_118_844.t15 30.0005
R2371 a_118_844.n15 a_118_844.t16 30.0005
R2372 a_118_844.n13 a_118_844.t13 30.0005
R2373 a_118_844.n13 a_118_844.t14 30.0005
R2374 a_118_844.n11 a_118_844.t11 30.0005
R2375 a_118_844.n11 a_118_844.t12 30.0005
R2376 a_118_844.n9 a_118_844.t9 30.0005
R2377 a_118_844.n9 a_118_844.t10 30.0005
R2378 a_118_844.n7 a_118_844.t7 30.0005
R2379 a_118_844.n7 a_118_844.t8 30.0005
R2380 a_118_844.n5 a_118_844.t5 30.0005
R2381 a_118_844.n5 a_118_844.t6 30.0005
R2382 a_118_844.n3 a_118_844.t3 30.0005
R2383 a_118_844.n3 a_118_844.t4 30.0005
R2384 a_118_844.n1 a_118_844.t1 30.0005
R2385 a_118_844.n1 a_118_844.t2 30.0005
R2386 a_118_844.n0 a_118_844.t0 10.0477
R2387 a_118_844.n0 a_118_844.t41 8.92179
R2388 a_118_844.n2 a_118_844.n0 1.02256
R2389 a_118_844.n16 a_118_844.n14 0.12364
R2390 a_118_844.n22 a_118_844.n20 0.12364
R2391 a_118_844.n28 a_118_844.n26 0.12364
R2392 a_118_844.n34 a_118_844.n32 0.12364
R2393 a_118_844.n6 a_118_844.n4 0.1227
R2394 a_118_844.n8 a_118_844.n6 0.1227
R2395 a_118_844.n10 a_118_844.n8 0.1227
R2396 a_118_844.n12 a_118_844.n10 0.1227
R2397 a_118_844.n4 a_118_844.n2 0.12223
R2398 a_118_844.n14 a_118_844.n12 0.12223
R2399 a_118_844.n18 a_118_844.n16 0.12223
R2400 a_118_844.n20 a_118_844.n18 0.12223
R2401 a_118_844.n24 a_118_844.n22 0.12223
R2402 a_118_844.n26 a_118_844.n24 0.12223
R2403 a_118_844.n30 a_118_844.n28 0.12223
R2404 a_118_844.n32 a_118_844.n30 0.12223
R2405 a_118_844.n36 a_118_844.n34 0.12223
R2406 a_118_844.n38 a_118_844.n36 0.12223
C2 HEN VGND 6.91777f
C3 HIN VGND 3.09291f
C4 a_5726_844# VGND 3.83933f **FLOATING
C5 a_5726_3376# VGND 3.85093f **FLOATING
C6 a_118_844.t0 VGND 0.59064f **FLOATING
C7 a_118_844.t41 VGND 0.37445f **FLOATING
C8 a_118_844.n0 VGND 3.6877f **FLOATING
C9 a_118_844.t2 VGND 0.00459f **FLOATING
C10 a_118_844.t1 VGND 0.00459f **FLOATING
C11 a_118_844.n1 VGND 0.01086f **FLOATING
C12 a_118_844.n2 VGND 0.1207f **FLOATING
C13 a_118_844.t4 VGND 0.00459f **FLOATING
C14 a_118_844.t3 VGND 0.00459f **FLOATING
C15 a_118_844.n3 VGND 0.01086f **FLOATING
C16 a_118_844.n4 VGND 0.05545f **FLOATING
C17 a_118_844.t6 VGND 0.00459f **FLOATING
C18 a_118_844.t5 VGND 0.00459f **FLOATING
C19 a_118_844.n5 VGND 0.01086f **FLOATING
C20 a_118_844.n6 VGND 0.0555f **FLOATING
C21 a_118_844.t8 VGND 0.00459f **FLOATING
C22 a_118_844.t7 VGND 0.00459f **FLOATING
C23 a_118_844.n7 VGND 0.01086f **FLOATING
C24 a_118_844.n8 VGND 0.0555f **FLOATING
C25 a_118_844.t10 VGND 0.00459f **FLOATING
C26 a_118_844.t9 VGND 0.00459f **FLOATING
C27 a_118_844.n9 VGND 0.01086f **FLOATING
C28 a_118_844.n10 VGND 0.0555f **FLOATING
C29 a_118_844.t12 VGND 0.00459f **FLOATING
C30 a_118_844.t11 VGND 0.00459f **FLOATING
C31 a_118_844.n11 VGND 0.01086f **FLOATING
C32 a_118_844.n12 VGND 0.05545f **FLOATING
C33 a_118_844.t14 VGND 0.00459f **FLOATING
C34 a_118_844.t13 VGND 0.00459f **FLOATING
C35 a_118_844.n13 VGND 0.01086f **FLOATING
C36 a_118_844.n14 VGND 0.05554f **FLOATING
C37 a_118_844.t16 VGND 0.00459f **FLOATING
C38 a_118_844.t15 VGND 0.00459f **FLOATING
C39 a_118_844.n15 VGND 0.01086f **FLOATING
C40 a_118_844.n16 VGND 0.05554f **FLOATING
C41 a_118_844.t18 VGND 0.00459f **FLOATING
C42 a_118_844.t17 VGND 0.00459f **FLOATING
C43 a_118_844.n17 VGND 0.01086f **FLOATING
C44 a_118_844.n18 VGND 0.05541f **FLOATING
C45 a_118_844.t20 VGND 0.00459f **FLOATING
C46 a_118_844.t19 VGND 0.00459f **FLOATING
C47 a_118_844.n19 VGND 0.01086f **FLOATING
C48 a_118_844.n20 VGND 0.05554f **FLOATING
C49 a_118_844.t22 VGND 0.00459f **FLOATING
C50 a_118_844.t21 VGND 0.00459f **FLOATING
C51 a_118_844.n21 VGND 0.01086f **FLOATING
C52 a_118_844.n22 VGND 0.05554f **FLOATING
C53 a_118_844.t24 VGND 0.00459f **FLOATING
C54 a_118_844.t23 VGND 0.00459f **FLOATING
C55 a_118_844.n23 VGND 0.01086f **FLOATING
C56 a_118_844.n24 VGND 0.05541f **FLOATING
C57 a_118_844.t26 VGND 0.00459f **FLOATING
C58 a_118_844.t25 VGND 0.00459f **FLOATING
C59 a_118_844.n25 VGND 0.01086f **FLOATING
C60 a_118_844.n26 VGND 0.05554f **FLOATING
C61 a_118_844.t28 VGND 0.00459f **FLOATING
C62 a_118_844.t27 VGND 0.00459f **FLOATING
C63 a_118_844.n27 VGND 0.01086f **FLOATING
C64 a_118_844.n28 VGND 0.05554f **FLOATING
C65 a_118_844.t30 VGND 0.00459f **FLOATING
C66 a_118_844.t29 VGND 0.00459f **FLOATING
C67 a_118_844.n29 VGND 0.01086f **FLOATING
C68 a_118_844.n30 VGND 0.05541f **FLOATING
C69 a_118_844.t32 VGND 0.00459f **FLOATING
C70 a_118_844.t31 VGND 0.00459f **FLOATING
C71 a_118_844.n31 VGND 0.01086f **FLOATING
C72 a_118_844.n32 VGND 0.05554f **FLOATING
C73 a_118_844.t34 VGND 0.00459f **FLOATING
C74 a_118_844.t33 VGND 0.00459f **FLOATING
C75 a_118_844.n33 VGND 0.01086f **FLOATING
C76 a_118_844.n34 VGND 0.05554f **FLOATING
C77 a_118_844.t36 VGND 0.00459f **FLOATING
C78 a_118_844.t35 VGND 0.00459f **FLOATING
C79 a_118_844.n35 VGND 0.01086f **FLOATING
C80 a_118_844.n36 VGND 0.05541f **FLOATING
C81 a_118_844.t38 VGND 0.00459f **FLOATING
C82 a_118_844.t37 VGND 0.00459f **FLOATING
C83 a_118_844.n37 VGND 0.01086f **FLOATING
C84 a_118_844.n38 VGND 0.10144f **FLOATING
C85 a_118_844.t39 VGND 0.00459f **FLOATING
C86 a_118_844.n39 VGND 0.01091f **FLOATING
C87 a_118_844.t40 VGND 0.00459f **FLOATING
C88 HIN.t0 VGND 0.5418f **FLOATING
C89 HIN.t1 VGND 0.5418f **FLOATING
C90 HIN.n0 VGND 2.78029f **FLOATING
C91 HEN.t0 VGND 0.02372f **FLOATING
C92 HEN.t1 VGND 0.02369f **FLOATING
C93 HEN.n0 VGND 0.05831f **FLOATING
C94 HEN.t2 VGND 0.02369f **FLOATING
C95 HEN.n1 VGND 0.03091f **FLOATING
C96 HEN.t3 VGND 0.02369f **FLOATING
C97 HEN.n2 VGND 0.03091f **FLOATING
C98 HEN.t4 VGND 0.02369f **FLOATING
C99 HEN.n3 VGND 0.03091f **FLOATING
C100 HEN.t5 VGND 0.02369f **FLOATING
C101 HEN.n4 VGND 0.03091f **FLOATING
C102 HEN.t6 VGND 0.02369f **FLOATING
C103 HEN.n5 VGND 0.03091f **FLOATING
C104 HEN.t7 VGND 0.02369f **FLOATING
C105 HEN.n6 VGND 0.03091f **FLOATING
C106 HEN.t8 VGND 0.02369f **FLOATING
C107 HEN.n7 VGND 0.03091f **FLOATING
C108 HEN.t9 VGND 0.02369f **FLOATING
C109 HEN.n8 VGND 0.03091f **FLOATING
C110 HEN.t10 VGND 0.02369f **FLOATING
C111 HEN.n9 VGND 0.03091f **FLOATING
C112 HEN.t11 VGND 0.02369f **FLOATING
C113 HEN.n10 VGND 0.03091f **FLOATING
C114 HEN.t12 VGND 0.02369f **FLOATING
C115 HEN.n11 VGND 0.03091f **FLOATING
C116 HEN.t13 VGND 0.02369f **FLOATING
C117 HEN.n12 VGND 0.03091f **FLOATING
C118 HEN.t14 VGND 0.02369f **FLOATING
C119 HEN.n13 VGND 0.03091f **FLOATING
C120 HEN.t15 VGND 0.02369f **FLOATING
C121 HEN.n14 VGND 0.03091f **FLOATING
C122 HEN.t16 VGND 0.02369f **FLOATING
C123 HEN.n15 VGND 0.03091f **FLOATING
C124 HEN.t17 VGND 0.02369f **FLOATING
C125 HEN.n16 VGND 0.03091f **FLOATING
C126 HEN.t18 VGND 0.02369f **FLOATING
C127 HEN.n17 VGND 0.03091f **FLOATING
C128 HEN.t19 VGND 0.02369f **FLOATING
C129 HEN.n18 VGND 0.03091f **FLOATING
C130 HEN.t20 VGND 0.02369f **FLOATING
C131 HEN.n19 VGND 0.03091f **FLOATING
C132 HEN.t21 VGND 0.02369f **FLOATING
C133 HEN.n20 VGND 0.03091f **FLOATING
C134 HEN.t22 VGND 0.02369f **FLOATING
C135 HEN.n21 VGND 0.03091f **FLOATING
C136 HEN.t23 VGND 0.02369f **FLOATING
C137 HEN.n22 VGND 0.03091f **FLOATING
C138 HEN.t24 VGND 0.02369f **FLOATING
C139 HEN.n23 VGND 0.03091f **FLOATING
C140 HEN.t25 VGND 0.02369f **FLOATING
C141 HEN.n24 VGND 0.03091f **FLOATING
C142 HEN.t26 VGND 0.02369f **FLOATING
C143 HEN.n25 VGND 0.03091f **FLOATING
C144 HEN.t27 VGND 0.02369f **FLOATING
C145 HEN.n26 VGND 0.03091f **FLOATING
C146 HEN.t28 VGND 0.02369f **FLOATING
C147 HEN.n27 VGND 0.03091f **FLOATING
C148 HEN.t29 VGND 0.02369f **FLOATING
C149 HEN.n28 VGND 0.03091f **FLOATING
C150 HEN.t30 VGND 0.02369f **FLOATING
C151 HEN.n29 VGND 0.03091f **FLOATING
C152 HEN.t31 VGND 0.02369f **FLOATING
C153 HEN.n30 VGND 0.03091f **FLOATING
C154 HEN.t32 VGND 0.02369f **FLOATING
C155 HEN.n31 VGND 0.03091f **FLOATING
C156 HEN.t33 VGND 0.02369f **FLOATING
C157 HEN.n32 VGND 0.03091f **FLOATING
C158 HEN.t34 VGND 0.02369f **FLOATING
C159 HEN.n33 VGND 0.03091f **FLOATING
C160 HEN.t35 VGND 0.02369f **FLOATING
C161 HEN.n34 VGND 0.03091f **FLOATING
C162 HEN.t36 VGND 0.02369f **FLOATING
C163 HEN.n35 VGND 0.03091f **FLOATING
C164 HEN.t37 VGND 0.02369f **FLOATING
C165 HEN.n36 VGND 0.03091f **FLOATING
C166 HEN.t38 VGND 0.02369f **FLOATING
C167 HEN.n37 VGND 0.03072f **FLOATING
C168 HEN.t39 VGND 0.02369f **FLOATING
C169 HEN.n38 VGND 0.05158f **FLOATING
