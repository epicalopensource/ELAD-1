* heater pre sf_27
.lib /foss/pdks/sky130A/libs.tech/ngspice/sky130.lib.spice sf
.include /foss/designs/ELAD-1/cells/ELAD1_HEATER/netlist/ELAD1_HEATER.spice
XDUT HIN HEN VGND  ELAD1_HEATER
VG0 VGND 0 0
VHEN HEN 0 1.8
VHIN HIN 0 1.8
.option rshunt=1e12
.temp 27
.control
set filetype=ascii
dc VHIN 0 1.8 0.05
wrdata results_dc/pre/sweeps/on_sf_27.txt i(VHIN)
alter VHEN dc=0
dc VHIN 0 1.8 0.05
wrdata results_dc/pre/sweeps/off_sf_27.txt i(VHIN)
alter VHEN dc=1.8
alter VHIN dc=1.8
dc VHEN 0 1.8 0.05
wrdata results_dc/pre/sweeps/hen_sf_27.txt i(VHIN)
quit
.endc
.end
