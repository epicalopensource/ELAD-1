* SPICE3 file created from ELAD1_HEATER_flat.ext - technology: sky130A

X0 VGND.t16 a_584_462# HEN.t28 VGND.t15 sky130_fd_pr__nfet_01v8 ad=0.25 pd=1.5 as=0.25 ps=1.5 w=1 l=0.15
X1 HEN.t0 a_5726_764# VGND.t0 sky130_fd_pr__res_high_po_5p73 l=26.02
X2 HEN.t32 a_584_462# VGND.t74 VGND.t73 sky130_fd_pr__nfet_01v8 ad=0.25 pd=1.5 as=0.25 ps=1.5 w=1 l=0.15
X3 VGND.t80 a_584_462# HEN.t38 VGND.t79 sky130_fd_pr__nfet_01v8 ad=0.5 pd=3 as=0.25 ps=1.5 w=1 l=0.15
X4 VGND.t72 a_584_462# HEN.t35 VGND.t71 sky130_fd_pr__nfet_01v8 ad=0.25 pd=1.5 as=0.25 ps=1.5 w=1 l=0.15
X5 HEN.t16 a_584_462# VGND.t62 VGND.t61 sky130_fd_pr__nfet_01v8 ad=0.25 pd=1.5 as=0.25 ps=1.5 w=1 l=0.15
X6 HEN.t3 a_584_462# VGND.t70 VGND.t69 sky130_fd_pr__nfet_01v8 ad=0.25 pd=1.5 as=0.25 ps=1.5 w=1 l=0.15
X7 HEN.t22 a_584_462# VGND.t78 VGND.t77 sky130_fd_pr__nfet_01v8 ad=0.25 pd=1.5 as=0.25 ps=1.5 w=1 l=0.15
X8 HIN.t1 a_5726_3296# VGND.t0 sky130_fd_pr__res_high_po_5p73 l=26.02
X9 VGND.t60 a_584_462# HEN.t29 VGND.t59 sky130_fd_pr__nfet_01v8 ad=0.25 pd=1.5 as=0.25 ps=1.5 w=1 l=0.15
X10 VGND.t68 a_584_462# HEN.t40 VGND.t67 sky130_fd_pr__nfet_01v8 ad=0.25 pd=1.5 as=0.25 ps=1.5 w=1 l=0.15
X11 VGND.t76 a_584_462# HEN.t19 VGND.t75 sky130_fd_pr__nfet_01v8 ad=0.25 pd=1.5 as=0.25 ps=1.5 w=1 l=0.15
X12 HEN.t12 a_584_462# VGND.t42 VGND.t41 sky130_fd_pr__nfet_01v8 ad=0.25 pd=1.5 as=0.25 ps=1.5 w=1 l=0.15
X13 HEN.t4 a_584_462# VGND.t58 VGND.t57 sky130_fd_pr__nfet_01v8 ad=0.25 pd=1.5 as=0.25 ps=1.5 w=1 l=0.15
X14 HEN.t25 a_584_462# VGND.t66 VGND.t65 sky130_fd_pr__nfet_01v8 ad=0.25 pd=1.5 as=0.25 ps=1.5 w=1 l=0.15
X15 VGND.t40 a_584_462# HEN.t36 VGND.t39 sky130_fd_pr__nfet_01v8 ad=0.25 pd=1.5 as=0.25 ps=1.5 w=1 l=0.15
X16 VGND.t48 a_584_462# HEN.t27 VGND.t47 sky130_fd_pr__nfet_01v8 ad=0.25 pd=1.5 as=0.25 ps=1.5 w=1 l=0.15
X17 VGND.t56 a_584_462# HEN.t24 VGND.t55 sky130_fd_pr__nfet_01v8 ad=0.25 pd=1.5 as=0.25 ps=1.5 w=1 l=0.15
X18 VGND.t64 a_584_462# HEN.t10 VGND.t63 sky130_fd_pr__nfet_01v8 ad=0.25 pd=1.5 as=0.25 ps=1.5 w=1 l=0.15
X19 HEN.t8 a_584_462# VGND.t46 VGND.t45 sky130_fd_pr__nfet_01v8 ad=0.25 pd=1.5 as=0.25 ps=1.5 w=1 l=0.15
X20 HEN.t41 a_584_462# VGND.t54 VGND.t53 sky130_fd_pr__nfet_01v8 ad=0.25 pd=1.5 as=0.25 ps=1.5 w=1 l=0.15
X21 VGND.t44 a_584_462# HEN.t34 VGND.t43 sky130_fd_pr__nfet_01v8 ad=0.25 pd=1.5 as=0.25 ps=1.5 w=1 l=0.15
X22 VGND.t52 a_584_462# HEN.t15 VGND.t51 sky130_fd_pr__nfet_01v8 ad=0.25 pd=1.5 as=0.25 ps=1.5 w=1 l=0.15
X23 HEN.t13 a_584_462# VGND.t2 VGND.t1 sky130_fd_pr__nfet_01v8 ad=0.25 pd=1.5 as=0.5 ps=3 w=1 l=0.15
X24 VGND.t28 a_584_462# HEN.t9 VGND.t27 sky130_fd_pr__nfet_01v8 ad=0.25 pd=1.5 as=0.25 ps=1.5 w=1 l=0.15
X25 VGND.t8 a_584_462# HEN.t31 VGND.t7 sky130_fd_pr__nfet_01v8 ad=0.25 pd=1.5 as=0.25 ps=1.5 w=1 l=0.15
X26 HEN.t5 a_584_462# VGND.t50 VGND.t49 sky130_fd_pr__nfet_01v8 ad=0.25 pd=1.5 as=0.25 ps=1.5 w=1 l=0.15
X27 HEN.t37 a_584_462# VGND.t26 VGND.t25 sky130_fd_pr__nfet_01v8 ad=0.25 pd=1.5 as=0.25 ps=1.5 w=1 l=0.15
X28 HEN.t17 a_584_462# VGND.t34 VGND.t33 sky130_fd_pr__nfet_01v8 ad=0.25 pd=1.5 as=0.25 ps=1.5 w=1 l=0.15
X29 HEN.t39 a_584_462# VGND.t6 VGND.t5 sky130_fd_pr__nfet_01v8 ad=0.25 pd=1.5 as=0.25 ps=1.5 w=1 l=0.15
X30 VGND.t24 a_584_462# HEN.t6 VGND.t23 sky130_fd_pr__nfet_01v8 ad=0.25 pd=1.5 as=0.25 ps=1.5 w=1 l=0.15
X31 VGND.t32 a_584_462# HEN.t23 VGND.t31 sky130_fd_pr__nfet_01v8 ad=0.25 pd=1.5 as=0.25 ps=1.5 w=1 l=0.15
X32 HIN.t0 a_5726_764# VGND.t0 sky130_fd_pr__res_high_po_5p73 l=26.02
X33 VGND.t4 a_584_462# HEN.t7 VGND.t3 sky130_fd_pr__nfet_01v8 ad=0.25 pd=1.5 as=0.25 ps=1.5 w=1 l=0.15
X34 HEN.t11 a_584_462# VGND.t14 VGND.t13 sky130_fd_pr__nfet_01v8 ad=0.25 pd=1.5 as=0.25 ps=1.5 w=1 l=0.15
X35 HEN.t21 a_584_462# VGND.t22 VGND.t21 sky130_fd_pr__nfet_01v8 ad=0.25 pd=1.5 as=0.25 ps=1.5 w=1 l=0.15
X36 HEN.t30 a_584_462# VGND.t30 VGND.t29 sky130_fd_pr__nfet_01v8 ad=0.25 pd=1.5 as=0.25 ps=1.5 w=1 l=0.15
X37 HEN.t20 a_584_462# VGND.t38 VGND.t37 sky130_fd_pr__nfet_01v8 ad=0.25 pd=1.5 as=0.25 ps=1.5 w=1 l=0.15
X38 VGND.t12 a_584_462# HEN.t18 VGND.t11 sky130_fd_pr__nfet_01v8 ad=0.25 pd=1.5 as=0.25 ps=1.5 w=1 l=0.15
X39 VGND.t20 a_584_462# HEN.t33 VGND.t19 sky130_fd_pr__nfet_01v8 ad=0.25 pd=1.5 as=0.25 ps=1.5 w=1 l=0.15
X40 VGND.t36 a_584_462# HEN.t26 VGND.t35 sky130_fd_pr__nfet_01v8 ad=0.25 pd=1.5 as=0.25 ps=1.5 w=1 l=0.15
X41 HEN.t1 a_5726_3296# VGND.t0 sky130_fd_pr__res_high_po_5p73 l=26.02
X42 HEN.t14 a_584_462# VGND.t10 VGND.t9 sky130_fd_pr__nfet_01v8 ad=0.25 pd=1.5 as=0.25 ps=1.5 w=1 l=0.15
X43 HEN.t2 a_584_462# VGND.t18 VGND.t17 sky130_fd_pr__nfet_01v8 ad=0.25 pd=1.5 as=0.25 ps=1.5 w=1 l=0.15
C0 a_5726_3296# a_5726_764# 0.1856f
C1 HEN HIN 3.87501f
C2 HEN a_584_462# 2.09882f
R0 HIN.n0 HIN.t1 9.06473
R1 HIN.n0 HIN.t0 9.06473
R2 HIN HIN.n0 0.111214
R3 HEN.n2 HEN.n0 103.594
R4 HEN.n2 HEN.n1 103.475
R5 HEN.n4 HEN.n3 103.475
R6 HEN.n6 HEN.n5 103.475
R7 HEN.n8 HEN.n7 103.475
R8 HEN.n10 HEN.n9 103.475
R9 HEN.n12 HEN.n11 103.475
R10 HEN.n14 HEN.n13 103.475
R11 HEN.n16 HEN.n15 103.475
R12 HEN.n18 HEN.n17 103.475
R13 HEN.n20 HEN.n19 103.475
R14 HEN.n22 HEN.n21 103.475
R15 HEN.n24 HEN.n23 103.475
R16 HEN.n26 HEN.n25 103.475
R17 HEN.n28 HEN.n27 103.475
R18 HEN.n30 HEN.n29 103.475
R19 HEN.n32 HEN.n31 103.475
R20 HEN.n34 HEN.n33 103.475
R21 HEN.n36 HEN.n35 103.475
R22 HEN.n40 HEN.n39 99.7185
R23 HEN.n0 HEN.t22 30.0005
R24 HEN.n0 HEN.t38 30.0005
R25 HEN.n1 HEN.t32 30.0005
R26 HEN.n1 HEN.t19 30.0005
R27 HEN.n3 HEN.t3 30.0005
R28 HEN.n3 HEN.t35 30.0005
R29 HEN.n5 HEN.t25 30.0005
R30 HEN.n5 HEN.t40 30.0005
R31 HEN.n7 HEN.t16 30.0005
R32 HEN.n7 HEN.t10 30.0005
R33 HEN.n9 HEN.t4 30.0005
R34 HEN.n9 HEN.t29 30.0005
R35 HEN.n11 HEN.t41 30.0005
R36 HEN.n11 HEN.t24 30.0005
R37 HEN.n13 HEN.t5 30.0005
R38 HEN.n13 HEN.t15 30.0005
R39 HEN.n15 HEN.t8 30.0005
R40 HEN.n15 HEN.t27 30.0005
R41 HEN.n17 HEN.t12 30.0005
R42 HEN.n17 HEN.t34 30.0005
R43 HEN.n19 HEN.t20 30.0005
R44 HEN.n19 HEN.t36 30.0005
R45 HEN.n21 HEN.t17 30.0005
R46 HEN.n21 HEN.t26 30.0005
R47 HEN.n23 HEN.t30 30.0005
R48 HEN.n23 HEN.t23 30.0005
R49 HEN.n25 HEN.t37 30.0005
R50 HEN.n25 HEN.t9 30.0005
R51 HEN.n27 HEN.t21 30.0005
R52 HEN.n27 HEN.t6 30.0005
R53 HEN.n29 HEN.t2 30.0005
R54 HEN.n29 HEN.t33 30.0005
R55 HEN.n31 HEN.t11 30.0005
R56 HEN.n31 HEN.t28 30.0005
R57 HEN.n33 HEN.t14 30.0005
R58 HEN.n33 HEN.t18 30.0005
R59 HEN.n35 HEN.t39 30.0005
R60 HEN.n35 HEN.t31 30.0005
R61 HEN.n39 HEN.t13 30.0005
R62 HEN.n39 HEN.t7 30.0005
R63 HEN.n37 HEN.t1 10.0477
R64 HEN.n37 HEN.t0 8.92179
R65 HEN.n40 HEN.n38 3.59895
R66 HEN HEN.n40 2.21421
R67 HEN.n38 HEN.n37 1.0288
R68 HEN.n26 HEN.n24 0.12364
R69 HEN.n20 HEN.n18 0.12364
R70 HEN.n14 HEN.n12 0.12364
R71 HEN.n8 HEN.n6 0.12364
R72 HEN.n36 HEN.n34 0.1227
R73 HEN.n34 HEN.n32 0.1227
R74 HEN.n32 HEN.n30 0.1227
R75 HEN.n30 HEN.n28 0.1227
R76 HEN.n38 HEN.n36 0.12223
R77 HEN.n28 HEN.n26 0.12223
R78 HEN.n24 HEN.n22 0.12223
R79 HEN.n22 HEN.n20 0.12223
R80 HEN.n18 HEN.n16 0.12223
R81 HEN.n16 HEN.n14 0.12223
R82 HEN.n12 HEN.n10 0.12223
R83 HEN.n10 HEN.n8 0.12223
R84 HEN.n6 HEN.n4 0.12223
R85 HEN.n4 HEN.n2 0.12223
R86 VGND.n1176 VGND.n11 21867
R87 VGND.n1175 VGND.n1174 1420.8
R88 VGND.n819 VGND.n302 749.457
R89 VGND.n1178 VGND.n4 668.087
R90 VGND.n359 VGND.n304 668.087
R91 VGND.n359 VGND.n303 585
R92 VGND.n572 VGND.n359 585
R93 VGND.n573 VGND.n358 585
R94 VGND.n575 VGND.n356 585
R95 VGND.n576 VGND.n355 585
R96 VGND.n353 VGND.n312 585
R97 VGND.n311 VGND.n303 585
R98 VGND.n580 VGND.n311 585
R99 VGND.n581 VGND.n310 585
R100 VGND.n582 VGND.n308 585
R101 VGND.n818 VGND.n304 585
R102 VGND.n571 VGND.n304 585
R103 VGND.n360 VGND.n296 585
R104 VGND.n361 VGND.n360 585
R105 VGND.n826 VGND.n297 585
R106 VGND.n567 VGND.n297 585
R107 VGND.n363 VGND.n289 585
R108 VGND.n566 VGND.n363 585
R109 VGND.n834 VGND.n290 585
R110 VGND.n565 VGND.n290 585
R111 VGND.n364 VGND.n282 585
R112 VGND.n365 VGND.n364 585
R113 VGND.n842 VGND.n283 585
R114 VGND.n561 VGND.n283 585
R115 VGND.n367 VGND.n275 585
R116 VGND.n560 VGND.n367 585
R117 VGND.n850 VGND.n276 585
R118 VGND.n559 VGND.n276 585
R119 VGND.n368 VGND.n268 585
R120 VGND.n369 VGND.n368 585
R121 VGND.n858 VGND.n269 585
R122 VGND.n555 VGND.n269 585
R123 VGND.n371 VGND.n261 585
R124 VGND.n554 VGND.n371 585
R125 VGND.n866 VGND.n262 585
R126 VGND.n553 VGND.n262 585
R127 VGND.n373 VGND.n372 585
R128 VGND.n374 VGND.n373 585
R129 VGND.n874 VGND.n254 585
R130 VGND.n549 VGND.n254 585
R131 VGND.n376 VGND.n255 585
R132 VGND.n548 VGND.n376 585
R133 VGND.n882 VGND.n247 585
R134 VGND.n547 VGND.n247 585
R135 VGND.n377 VGND.n248 585
R136 VGND.n378 VGND.n377 585
R137 VGND.n890 VGND.n240 585
R138 VGND.n543 VGND.n240 585
R139 VGND.n380 VGND.n241 585
R140 VGND.n542 VGND.n380 585
R141 VGND.n898 VGND.n233 585
R142 VGND.n541 VGND.n233 585
R143 VGND.n381 VGND.n234 585
R144 VGND.n382 VGND.n381 585
R145 VGND.n906 VGND.n227 585
R146 VGND.n537 VGND.n227 585
R147 VGND.n384 VGND.n220 585
R148 VGND.n536 VGND.n384 585
R149 VGND.n914 VGND.n221 585
R150 VGND.n535 VGND.n221 585
R151 VGND.n385 VGND.n213 585
R152 VGND.n386 VGND.n385 585
R153 VGND.n922 VGND.n214 585
R154 VGND.n531 VGND.n214 585
R155 VGND.n388 VGND.n206 585
R156 VGND.n530 VGND.n388 585
R157 VGND.n930 VGND.n207 585
R158 VGND.n529 VGND.n207 585
R159 VGND.n389 VGND.n199 585
R160 VGND.n390 VGND.n389 585
R161 VGND.n938 VGND.n200 585
R162 VGND.n525 VGND.n200 585
R163 VGND.n393 VGND.n392 585
R164 VGND.n524 VGND.n393 585
R165 VGND.n946 VGND.n192 585
R166 VGND.n523 VGND.n192 585
R167 VGND.n394 VGND.n193 585
R168 VGND.n395 VGND.n394 585
R169 VGND.n954 VGND.n185 585
R170 VGND.n519 VGND.n185 585
R171 VGND.n397 VGND.n186 585
R172 VGND.n518 VGND.n397 585
R173 VGND.n962 VGND.n178 585
R174 VGND.n517 VGND.n178 585
R175 VGND.n398 VGND.n179 585
R176 VGND.n399 VGND.n398 585
R177 VGND.n970 VGND.n171 585
R178 VGND.n513 VGND.n171 585
R179 VGND.n401 VGND.n172 585
R180 VGND.n512 VGND.n401 585
R181 VGND.n978 VGND.n164 585
R182 VGND.n511 VGND.n164 585
R183 VGND.n402 VGND.n165 585
R184 VGND.n403 VGND.n402 585
R185 VGND.t0 VGND.n158 585
R186 VGND.n507 VGND.n158 585
R187 VGND.n405 VGND.n151 585
R188 VGND.n506 VGND.n405 585
R189 VGND.n993 VGND.n152 585
R190 VGND.n505 VGND.n152 585
R191 VGND.n406 VGND.n144 585
R192 VGND.n407 VGND.n406 585
R193 VGND.n1001 VGND.n145 585
R194 VGND.n501 VGND.n145 585
R195 VGND.n409 VGND.n137 585
R196 VGND.n500 VGND.n409 585
R197 VGND.n1009 VGND.n138 585
R198 VGND.n499 VGND.n138 585
R199 VGND.n410 VGND.n130 585
R200 VGND.n411 VGND.n410 585
R201 VGND.n1017 VGND.n131 585
R202 VGND.n495 VGND.n131 585
R203 VGND.n414 VGND.n413 585
R204 VGND.n494 VGND.n414 585
R205 VGND.n1025 VGND.n123 585
R206 VGND.n493 VGND.n123 585
R207 VGND.n415 VGND.n124 585
R208 VGND.n416 VGND.n415 585
R209 VGND.n1033 VGND.n116 585
R210 VGND.n489 VGND.n116 585
R211 VGND.n418 VGND.n117 585
R212 VGND.n488 VGND.n418 585
R213 VGND.n1041 VGND.n109 585
R214 VGND.n487 VGND.n109 585
R215 VGND.n419 VGND.n110 585
R216 VGND.n420 VGND.n419 585
R217 VGND.n1049 VGND.n102 585
R218 VGND.n483 VGND.n102 585
R219 VGND.n422 VGND.n103 585
R220 VGND.n482 VGND.n422 585
R221 VGND.n1057 VGND.n96 585
R222 VGND.n481 VGND.n96 585
R223 VGND.n423 VGND.n89 585
R224 VGND.n424 VGND.n423 585
R225 VGND.n1065 VGND.n90 585
R226 VGND.n477 VGND.n90 585
R227 VGND.n426 VGND.n82 585
R228 VGND.n476 VGND.n426 585
R229 VGND.n1073 VGND.n83 585
R230 VGND.n475 VGND.n83 585
R231 VGND.n427 VGND.n75 585
R232 VGND.n428 VGND.n427 585
R233 VGND.n1081 VGND.n76 585
R234 VGND.n471 VGND.n76 585
R235 VGND.n430 VGND.n68 585
R236 VGND.n470 VGND.n430 585
R237 VGND.n1089 VGND.n69 585
R238 VGND.n469 VGND.n69 585
R239 VGND.n432 VGND.n431 585
R240 VGND.n433 VGND.n432 585
R241 VGND.n1097 VGND.n61 585
R242 VGND.n465 VGND.n61 585
R243 VGND.n435 VGND.n62 585
R244 VGND.n464 VGND.n435 585
R245 VGND.n1105 VGND.n54 585
R246 VGND.n463 VGND.n54 585
R247 VGND.n436 VGND.n55 585
R248 VGND.n437 VGND.n436 585
R249 VGND.n1113 VGND.n47 585
R250 VGND.n459 VGND.n47 585
R251 VGND.n439 VGND.n48 585
R252 VGND.n458 VGND.n439 585
R253 VGND.n1121 VGND.n40 585
R254 VGND.n457 VGND.n40 585
R255 VGND.n440 VGND.n41 585
R256 VGND.n441 VGND.n440 585
R257 VGND.n1129 VGND.n34 585
R258 VGND.n453 VGND.n34 585
R259 VGND.n443 VGND.n26 585
R260 VGND.n452 VGND.n443 585
R261 VGND.n1138 VGND.n27 585
R262 VGND.n451 VGND.n27 585
R263 VGND.n444 VGND.n19 585
R264 VGND.n445 VGND.n444 585
R265 VGND.n1147 VGND.n20 585
R266 VGND.n447 VGND.n20 585
R267 VGND.n7 VGND.n6 585
R268 VGND.n6 VGND.n5 585
R269 VGND.n1178 VGND.n1177 585
R270 VGND.n1179 VGND.n1178 585
R271 VGND.n1173 VGND.n14 585
R272 VGND.n1155 VGND.n15 585
R273 VGND.n1169 VGND.n1156 585
R274 VGND.n1168 VGND.n1158 585
R275 VGND.n1167 VGND.n1159 585
R276 VGND.n1164 VGND.n1163 585
R277 VGND.n1162 VGND.n3 585
R278 VGND.n1180 VGND.n4 585
R279 VGND.n1177 VGND.n1176 585
R280 VGND.n1176 VGND.n1175 585
R281 VGND.n10 VGND.n7 585
R282 VGND.n1144 VGND.n10 585
R283 VGND.n1147 VGND.n1146 585
R284 VGND.n1146 VGND.n1145 585
R285 VGND.n21 VGND.n19 585
R286 VGND.n22 VGND.n21 585
R287 VGND.n1139 VGND.n1138 585
R288 VGND.n1140 VGND.n1139 585
R289 VGND.n26 VGND.n25 585
R290 VGND.n25 VGND.n24 585
R291 VGND.n1129 VGND.n1128 585
R292 VGND.n1128 VGND.n1127 585
R293 VGND.n41 VGND.n35 585
R294 VGND.n36 VGND.n35 585
R295 VGND.n1122 VGND.n1121 585
R296 VGND.n1123 VGND.n1122 585
R297 VGND.n48 VGND.n39 585
R298 VGND.n39 VGND.n38 585
R299 VGND.n1113 VGND.n1112 585
R300 VGND.n1112 VGND.n1111 585
R301 VGND.n55 VGND.n49 585
R302 VGND.n50 VGND.n49 585
R303 VGND.n1106 VGND.n1105 585
R304 VGND.n1107 VGND.n1106 585
R305 VGND.n62 VGND.n53 585
R306 VGND.n53 VGND.n52 585
R307 VGND.n1097 VGND.n1096 585
R308 VGND.n1096 VGND.n1095 585
R309 VGND.n431 VGND.n63 585
R310 VGND.n64 VGND.n63 585
R311 VGND.n1090 VGND.n1089 585
R312 VGND.n1091 VGND.n1090 585
R313 VGND.n68 VGND.n67 585
R314 VGND.n67 VGND.n66 585
R315 VGND.n1081 VGND.n1080 585
R316 VGND.n1080 VGND.n1079 585
R317 VGND.n77 VGND.n75 585
R318 VGND.n78 VGND.n77 585
R319 VGND.n1074 VGND.n1073 585
R320 VGND.n1075 VGND.n1074 585
R321 VGND.n82 VGND.n81 585
R322 VGND.n81 VGND.n80 585
R323 VGND.n1065 VGND.n1064 585
R324 VGND.n1064 VGND.n1063 585
R325 VGND.n91 VGND.n89 585
R326 VGND.n92 VGND.n91 585
R327 VGND.n1058 VGND.n1057 585
R328 VGND.n1059 VGND.n1058 585
R329 VGND.n103 VGND.n95 585
R330 VGND.n95 VGND.n94 585
R331 VGND.n1049 VGND.n1048 585
R332 VGND.n1048 VGND.n1047 585
R333 VGND.n110 VGND.n104 585
R334 VGND.n105 VGND.n104 585
R335 VGND.n1042 VGND.n1041 585
R336 VGND.n1043 VGND.n1042 585
R337 VGND.n117 VGND.n108 585
R338 VGND.n108 VGND.n107 585
R339 VGND.n1033 VGND.n1032 585
R340 VGND.n1032 VGND.n1031 585
R341 VGND.n124 VGND.n118 585
R342 VGND.n119 VGND.n118 585
R343 VGND.n1026 VGND.n1025 585
R344 VGND.n1027 VGND.n1026 585
R345 VGND.n413 VGND.n122 585
R346 VGND.n122 VGND.n121 585
R347 VGND.n1017 VGND.n1016 585
R348 VGND.n1016 VGND.n1015 585
R349 VGND.n132 VGND.n130 585
R350 VGND.n133 VGND.n132 585
R351 VGND.n1010 VGND.n1009 585
R352 VGND.n1011 VGND.n1010 585
R353 VGND.n137 VGND.n136 585
R354 VGND.n136 VGND.n135 585
R355 VGND.n1001 VGND.n1000 585
R356 VGND.n1000 VGND.n999 585
R357 VGND.n146 VGND.n144 585
R358 VGND.n147 VGND.n146 585
R359 VGND.n994 VGND.n993 585
R360 VGND.n995 VGND.n994 585
R361 VGND.n151 VGND.n150 585
R362 VGND.n150 VGND.n149 585
R363 VGND.t0 VGND.n985 585
R364 VGND.n985 VGND.n984 585
R365 VGND.n165 VGND.n159 585
R366 VGND.n160 VGND.n159 585
R367 VGND.n979 VGND.n978 585
R368 VGND.n980 VGND.n979 585
R369 VGND.n172 VGND.n163 585
R370 VGND.n163 VGND.n162 585
R371 VGND.n970 VGND.n969 585
R372 VGND.n969 VGND.n968 585
R373 VGND.n179 VGND.n173 585
R374 VGND.n174 VGND.n173 585
R375 VGND.n963 VGND.n962 585
R376 VGND.n964 VGND.n963 585
R377 VGND.n186 VGND.n177 585
R378 VGND.n177 VGND.n176 585
R379 VGND.n954 VGND.n953 585
R380 VGND.n953 VGND.n952 585
R381 VGND.n193 VGND.n187 585
R382 VGND.n188 VGND.n187 585
R383 VGND.n947 VGND.n946 585
R384 VGND.n948 VGND.n947 585
R385 VGND.n392 VGND.n191 585
R386 VGND.n191 VGND.n190 585
R387 VGND.n938 VGND.n937 585
R388 VGND.n937 VGND.n936 585
R389 VGND.n201 VGND.n199 585
R390 VGND.n202 VGND.n201 585
R391 VGND.n931 VGND.n930 585
R392 VGND.n932 VGND.n931 585
R393 VGND.n206 VGND.n205 585
R394 VGND.n205 VGND.n204 585
R395 VGND.n922 VGND.n921 585
R396 VGND.n921 VGND.n920 585
R397 VGND.n215 VGND.n213 585
R398 VGND.n216 VGND.n215 585
R399 VGND.n915 VGND.n914 585
R400 VGND.n916 VGND.n915 585
R401 VGND.n220 VGND.n219 585
R402 VGND.n219 VGND.n218 585
R403 VGND.n906 VGND.n905 585
R404 VGND.n905 VGND.n904 585
R405 VGND.n234 VGND.n228 585
R406 VGND.n229 VGND.n228 585
R407 VGND.n899 VGND.n898 585
R408 VGND.n900 VGND.n899 585
R409 VGND.n241 VGND.n232 585
R410 VGND.n232 VGND.n231 585
R411 VGND.n890 VGND.n889 585
R412 VGND.n889 VGND.n888 585
R413 VGND.n248 VGND.n242 585
R414 VGND.n243 VGND.n242 585
R415 VGND.n883 VGND.n882 585
R416 VGND.n884 VGND.n883 585
R417 VGND.n255 VGND.n246 585
R418 VGND.n246 VGND.n245 585
R419 VGND.n874 VGND.n873 585
R420 VGND.n873 VGND.n872 585
R421 VGND.n372 VGND.n256 585
R422 VGND.n257 VGND.n256 585
R423 VGND.n867 VGND.n866 585
R424 VGND.n868 VGND.n867 585
R425 VGND.n261 VGND.n260 585
R426 VGND.n260 VGND.n259 585
R427 VGND.n858 VGND.n857 585
R428 VGND.n857 VGND.n856 585
R429 VGND.n270 VGND.n268 585
R430 VGND.n271 VGND.n270 585
R431 VGND.n851 VGND.n850 585
R432 VGND.n852 VGND.n851 585
R433 VGND.n275 VGND.n274 585
R434 VGND.n274 VGND.n273 585
R435 VGND.n842 VGND.n841 585
R436 VGND.n841 VGND.n840 585
R437 VGND.n284 VGND.n282 585
R438 VGND.n285 VGND.n284 585
R439 VGND.n835 VGND.n834 585
R440 VGND.n836 VGND.n835 585
R441 VGND.n289 VGND.n288 585
R442 VGND.n288 VGND.n287 585
R443 VGND.n826 VGND.n825 585
R444 VGND.n825 VGND.n824 585
R445 VGND.n298 VGND.n296 585
R446 VGND.n299 VGND.n298 585
R447 VGND.n819 VGND.n818 585
R448 VGND.n820 VGND.n819 585
R449 VGND.n812 VGND.n811 585
R450 VGND.n809 VGND.n585 585
R451 VGND.n808 VGND.n807 585
R452 VGND.n801 VGND.n587 585
R453 VGND.n802 VGND.n303 585
R454 VGND.n803 VGND.n802 585
R455 VGND.n800 VGND.n589 585
R456 VGND.n798 VGND.n797 585
R457 VGND.n591 VGND.n590 585
R458 VGND.n793 VGND.n792 585
R459 VGND.n790 VGND.n303 585
R460 VGND.n790 VGND.n593 585
R461 VGND.n789 VGND.n788 585
R462 VGND.n598 VGND.n595 585
R463 VGND.n784 VGND.n783 585
R464 VGND.n781 VGND.n597 585
R465 VGND.n780 VGND.n599 585
R466 VGND.n778 VGND.n777 585
R467 VGND.n601 VGND.n600 585
R468 VGND.n772 VGND.n771 585
R469 VGND.n769 VGND.n303 585
R470 VGND.n769 VGND.n603 585
R471 VGND.n768 VGND.n767 585
R472 VGND.n761 VGND.n605 585
R473 VGND.n762 VGND.n303 585
R474 VGND.n763 VGND.n762 585
R475 VGND.n760 VGND.n607 585
R476 VGND.n758 VGND.n757 585
R477 VGND.n608 VGND.n303 585
R478 VGND.n609 VGND.n608 585
R479 VGND.n753 VGND.n752 585
R480 VGND.n750 VGND.n611 585
R481 VGND.n749 VGND.n748 585
R482 VGND.n742 VGND.n613 585
R483 VGND.n743 VGND.n303 585
R484 VGND.n744 VGND.n743 585
R485 VGND.n741 VGND.n615 585
R486 VGND.n739 VGND.n738 585
R487 VGND.n617 VGND.n616 585
R488 VGND.n734 VGND.n733 585
R489 VGND.n731 VGND.n619 585
R490 VGND.n729 VGND.n728 585
R491 VGND.n621 VGND.n620 585
R492 VGND.n724 VGND.n723 585
R493 VGND.n721 VGND.n303 585
R494 VGND.n721 VGND.n623 585
R495 VGND.n720 VGND.n624 585
R496 VGND.n718 VGND.n717 585
R497 VGND.n626 VGND.n625 585
R498 VGND.n712 VGND.n711 585
R499 VGND.n709 VGND.n628 585
R500 VGND.n707 VGND.n706 585
R501 VGND.n630 VGND.n629 585
R502 VGND.n702 VGND.n701 585
R503 VGND.n699 VGND.n303 585
R504 VGND.n699 VGND.n632 585
R505 VGND.n698 VGND.n697 585
R506 VGND.n691 VGND.n634 585
R507 VGND.n693 VGND.n692 585
R508 VGND.n689 VGND.n636 585
R509 VGND.n688 VGND.n303 585
R510 VGND.n688 VGND.n687 585
R511 VGND.n638 VGND.n637 585
R512 VGND.n683 VGND.n682 585
R513 VGND.n680 VGND.n640 585
R514 VGND.n678 VGND.n677 585
R515 VGND.n642 VGND.n641 585
R516 VGND.n673 VGND.n672 585
R517 VGND.n670 VGND.n303 585
R518 VGND.n670 VGND.n644 585
R519 VGND.n669 VGND.n668 585
R520 VGND.n662 VGND.n646 585
R521 VGND.n664 VGND.n663 585
R522 VGND.n660 VGND.n648 585
R523 VGND.n659 VGND.n649 585
R524 VGND.n657 VGND.n656 585
R525 VGND.n652 VGND.n651 585
R526 VGND.n302 VGND.n301 585
R527 VGND.n811 VGND.n305 458.24
R528 VGND.n14 VGND.n11 376.87
R529 VGND.n308 VGND.n305 376.87
R530 VGND.n1163 VGND.n1162 308.349
R531 VGND.n1159 VGND.n1158 308.349
R532 VGND.n1156 VGND.n1155 308.349
R533 VGND.n1176 VGND.n10 308.349
R534 VGND.n1146 VGND.n10 308.349
R535 VGND.n1146 VGND.n21 308.349
R536 VGND.n1139 VGND.n21 308.349
R537 VGND.n1139 VGND.n25 308.349
R538 VGND.n1128 VGND.n25 308.349
R539 VGND.n1128 VGND.n35 308.349
R540 VGND.n1122 VGND.n35 308.349
R541 VGND.n1122 VGND.n39 308.349
R542 VGND.n1112 VGND.n39 308.349
R543 VGND.n1112 VGND.n49 308.349
R544 VGND.n1106 VGND.n49 308.349
R545 VGND.n1106 VGND.n53 308.349
R546 VGND.n1096 VGND.n53 308.349
R547 VGND.n1096 VGND.n63 308.349
R548 VGND.n1090 VGND.n63 308.349
R549 VGND.n1090 VGND.n67 308.349
R550 VGND.n1080 VGND.n67 308.349
R551 VGND.n1080 VGND.n77 308.349
R552 VGND.n1074 VGND.n77 308.349
R553 VGND.n1074 VGND.n81 308.349
R554 VGND.n1064 VGND.n81 308.349
R555 VGND.n1064 VGND.n91 308.349
R556 VGND.n1058 VGND.n91 308.349
R557 VGND.n1058 VGND.n95 308.349
R558 VGND.n1048 VGND.n95 308.349
R559 VGND.n1048 VGND.n104 308.349
R560 VGND.n1042 VGND.n104 308.349
R561 VGND.n1042 VGND.n108 308.349
R562 VGND.n1032 VGND.n108 308.349
R563 VGND.n1032 VGND.n118 308.349
R564 VGND.n1026 VGND.n118 308.349
R565 VGND.n1026 VGND.n122 308.349
R566 VGND.n1016 VGND.n122 308.349
R567 VGND.n1016 VGND.n132 308.349
R568 VGND.n1010 VGND.n132 308.349
R569 VGND.n1010 VGND.n136 308.349
R570 VGND.n1000 VGND.n136 308.349
R571 VGND.n1000 VGND.n146 308.349
R572 VGND.n994 VGND.n146 308.349
R573 VGND.n994 VGND.n150 308.349
R574 VGND.n985 VGND.n150 308.349
R575 VGND.n985 VGND.n159 308.349
R576 VGND.n979 VGND.n159 308.349
R577 VGND.n979 VGND.n163 308.349
R578 VGND.n969 VGND.n163 308.349
R579 VGND.n969 VGND.n173 308.349
R580 VGND.n963 VGND.n173 308.349
R581 VGND.n963 VGND.n177 308.349
R582 VGND.n953 VGND.n177 308.349
R583 VGND.n953 VGND.n187 308.349
R584 VGND.n947 VGND.n187 308.349
R585 VGND.n947 VGND.n191 308.349
R586 VGND.n937 VGND.n191 308.349
R587 VGND.n937 VGND.n201 308.349
R588 VGND.n931 VGND.n201 308.349
R589 VGND.n931 VGND.n205 308.349
R590 VGND.n921 VGND.n205 308.349
R591 VGND.n921 VGND.n215 308.349
R592 VGND.n915 VGND.n215 308.349
R593 VGND.n915 VGND.n219 308.349
R594 VGND.n905 VGND.n219 308.349
R595 VGND.n905 VGND.n228 308.349
R596 VGND.n899 VGND.n228 308.349
R597 VGND.n899 VGND.n232 308.349
R598 VGND.n889 VGND.n232 308.349
R599 VGND.n889 VGND.n242 308.349
R600 VGND.n883 VGND.n242 308.349
R601 VGND.n883 VGND.n246 308.349
R602 VGND.n873 VGND.n246 308.349
R603 VGND.n873 VGND.n256 308.349
R604 VGND.n867 VGND.n256 308.349
R605 VGND.n867 VGND.n260 308.349
R606 VGND.n857 VGND.n260 308.349
R607 VGND.n857 VGND.n270 308.349
R608 VGND.n851 VGND.n270 308.349
R609 VGND.n851 VGND.n274 308.349
R610 VGND.n841 VGND.n274 308.349
R611 VGND.n841 VGND.n284 308.349
R612 VGND.n835 VGND.n284 308.349
R613 VGND.n835 VGND.n288 308.349
R614 VGND.n825 VGND.n288 308.349
R615 VGND.n825 VGND.n298 308.349
R616 VGND.n819 VGND.n298 308.349
R617 VGND.n809 VGND.n808 308.349
R618 VGND.n802 VGND.n801 308.349
R619 VGND.n802 VGND.n800 308.349
R620 VGND.n798 VGND.n590 308.349
R621 VGND.n792 VGND.n790 308.349
R622 VGND.n790 VGND.n789 308.349
R623 VGND.n783 VGND.n598 308.349
R624 VGND.n781 VGND.n780 308.349
R625 VGND.n778 VGND.n600 308.349
R626 VGND.n771 VGND.n769 308.349
R627 VGND.n769 VGND.n768 308.349
R628 VGND.n762 VGND.n761 308.349
R629 VGND.n762 VGND.n760 308.349
R630 VGND.n758 VGND.n608 308.349
R631 VGND.n752 VGND.n608 308.349
R632 VGND.n750 VGND.n749 308.349
R633 VGND.n743 VGND.n742 308.349
R634 VGND.n743 VGND.n741 308.349
R635 VGND.n739 VGND.n616 308.349
R636 VGND.n733 VGND.n731 308.349
R637 VGND.n729 VGND.n620 308.349
R638 VGND.n723 VGND.n721 308.349
R639 VGND.n721 VGND.n720 308.349
R640 VGND.n718 VGND.n625 308.349
R641 VGND.n711 VGND.n709 308.349
R642 VGND.n707 VGND.n629 308.349
R643 VGND.n701 VGND.n699 308.349
R644 VGND.n699 VGND.n698 308.349
R645 VGND.n692 VGND.n691 308.349
R646 VGND.n689 VGND.n688 308.349
R647 VGND.n688 VGND.n637 308.349
R648 VGND.n682 VGND.n680 308.349
R649 VGND.n678 VGND.n641 308.349
R650 VGND.n672 VGND.n670 308.349
R651 VGND.n670 VGND.n669 308.349
R652 VGND.n663 VGND.n662 308.349
R653 VGND.n660 VGND.n659 308.349
R654 VGND.n657 VGND.n651 308.349
R655 VGND.n1178 VGND.n6 308.349
R656 VGND.n20 VGND.n6 308.349
R657 VGND.n444 VGND.n20 308.349
R658 VGND.n444 VGND.n27 308.349
R659 VGND.n443 VGND.n27 308.349
R660 VGND.n443 VGND.n34 308.349
R661 VGND.n440 VGND.n34 308.349
R662 VGND.n440 VGND.n40 308.349
R663 VGND.n439 VGND.n40 308.349
R664 VGND.n439 VGND.n47 308.349
R665 VGND.n436 VGND.n47 308.349
R666 VGND.n436 VGND.n54 308.349
R667 VGND.n435 VGND.n54 308.349
R668 VGND.n435 VGND.n61 308.349
R669 VGND.n432 VGND.n61 308.349
R670 VGND.n432 VGND.n69 308.349
R671 VGND.n430 VGND.n69 308.349
R672 VGND.n430 VGND.n76 308.349
R673 VGND.n427 VGND.n76 308.349
R674 VGND.n427 VGND.n83 308.349
R675 VGND.n426 VGND.n83 308.349
R676 VGND.n426 VGND.n90 308.349
R677 VGND.n423 VGND.n90 308.349
R678 VGND.n423 VGND.n96 308.349
R679 VGND.n422 VGND.n96 308.349
R680 VGND.n422 VGND.n102 308.349
R681 VGND.n419 VGND.n102 308.349
R682 VGND.n419 VGND.n109 308.349
R683 VGND.n418 VGND.n109 308.349
R684 VGND.n418 VGND.n116 308.349
R685 VGND.n415 VGND.n116 308.349
R686 VGND.n415 VGND.n123 308.349
R687 VGND.n414 VGND.n123 308.349
R688 VGND.n414 VGND.n131 308.349
R689 VGND.n410 VGND.n131 308.349
R690 VGND.n410 VGND.n138 308.349
R691 VGND.n409 VGND.n138 308.349
R692 VGND.n409 VGND.n145 308.349
R693 VGND.n406 VGND.n145 308.349
R694 VGND.n406 VGND.n152 308.349
R695 VGND.n405 VGND.n152 308.349
R696 VGND.n405 VGND.n158 308.349
R697 VGND.n402 VGND.n158 308.349
R698 VGND.n402 VGND.n164 308.349
R699 VGND.n401 VGND.n164 308.349
R700 VGND.n401 VGND.n171 308.349
R701 VGND.n398 VGND.n171 308.349
R702 VGND.n398 VGND.n178 308.349
R703 VGND.n397 VGND.n178 308.349
R704 VGND.n397 VGND.n185 308.349
R705 VGND.n394 VGND.n185 308.349
R706 VGND.n394 VGND.n192 308.349
R707 VGND.n393 VGND.n192 308.349
R708 VGND.n393 VGND.n200 308.349
R709 VGND.n389 VGND.n200 308.349
R710 VGND.n389 VGND.n207 308.349
R711 VGND.n388 VGND.n207 308.349
R712 VGND.n388 VGND.n214 308.349
R713 VGND.n385 VGND.n214 308.349
R714 VGND.n385 VGND.n221 308.349
R715 VGND.n384 VGND.n221 308.349
R716 VGND.n384 VGND.n227 308.349
R717 VGND.n381 VGND.n227 308.349
R718 VGND.n381 VGND.n233 308.349
R719 VGND.n380 VGND.n233 308.349
R720 VGND.n380 VGND.n240 308.349
R721 VGND.n377 VGND.n240 308.349
R722 VGND.n377 VGND.n247 308.349
R723 VGND.n376 VGND.n247 308.349
R724 VGND.n376 VGND.n254 308.349
R725 VGND.n373 VGND.n254 308.349
R726 VGND.n373 VGND.n262 308.349
R727 VGND.n371 VGND.n262 308.349
R728 VGND.n371 VGND.n269 308.349
R729 VGND.n368 VGND.n269 308.349
R730 VGND.n368 VGND.n276 308.349
R731 VGND.n367 VGND.n276 308.349
R732 VGND.n367 VGND.n283 308.349
R733 VGND.n364 VGND.n283 308.349
R734 VGND.n364 VGND.n290 308.349
R735 VGND.n363 VGND.n290 308.349
R736 VGND.n363 VGND.n297 308.349
R737 VGND.n360 VGND.n297 308.349
R738 VGND.n360 VGND.n304 308.349
R739 VGND.n359 VGND.n358 308.349
R740 VGND.n356 VGND.n355 308.349
R741 VGND.n353 VGND.n311 308.349
R742 VGND.n311 VGND.n310 308.349
R743 VGND.n818 VGND.n817 292.5
R744 VGND.n817 VGND.n816 292.5
R745 VGND.n296 VGND.n295 292.5
R746 VGND.n295 VGND.n294 292.5
R747 VGND.n827 VGND.n826 292.5
R748 VGND.n828 VGND.n827 292.5
R749 VGND.n291 VGND.n289 292.5
R750 VGND.n292 VGND.n291 292.5
R751 VGND.n834 VGND.n833 292.5
R752 VGND.n833 VGND.n832 292.5
R753 VGND.n282 VGND.n281 292.5
R754 VGND.n281 VGND.n280 292.5
R755 VGND.n843 VGND.n842 292.5
R756 VGND.n844 VGND.n843 292.5
R757 VGND.n277 VGND.n275 292.5
R758 VGND.n278 VGND.n277 292.5
R759 VGND.n850 VGND.n849 292.5
R760 VGND.n849 VGND.n848 292.5
R761 VGND.n268 VGND.n267 292.5
R762 VGND.n267 VGND.n266 292.5
R763 VGND.n859 VGND.n858 292.5
R764 VGND.n860 VGND.n859 292.5
R765 VGND.n263 VGND.n261 292.5
R766 VGND.n264 VGND.n263 292.5
R767 VGND.n866 VGND.n865 292.5
R768 VGND.n865 VGND.n864 292.5
R769 VGND.n372 VGND.n253 292.5
R770 VGND.n253 VGND.n252 292.5
R771 VGND.n875 VGND.n874 292.5
R772 VGND.n876 VGND.n875 292.5
R773 VGND.n255 VGND.n249 292.5
R774 VGND.n250 VGND.n249 292.5
R775 VGND.n882 VGND.n881 292.5
R776 VGND.n881 VGND.n880 292.5
R777 VGND.n248 VGND.n239 292.5
R778 VGND.n239 VGND.n238 292.5
R779 VGND.n891 VGND.n890 292.5
R780 VGND.n892 VGND.n891 292.5
R781 VGND.n241 VGND.n235 292.5
R782 VGND.n236 VGND.n235 292.5
R783 VGND.n898 VGND.n897 292.5
R784 VGND.n897 VGND.n896 292.5
R785 VGND.n234 VGND.n226 292.5
R786 VGND.n226 VGND.n225 292.5
R787 VGND.n907 VGND.n906 292.5
R788 VGND.n908 VGND.n907 292.5
R789 VGND.n222 VGND.n220 292.5
R790 VGND.n223 VGND.n222 292.5
R791 VGND.n914 VGND.n913 292.5
R792 VGND.n913 VGND.n912 292.5
R793 VGND.n213 VGND.n212 292.5
R794 VGND.n212 VGND.n211 292.5
R795 VGND.n923 VGND.n922 292.5
R796 VGND.n924 VGND.n923 292.5
R797 VGND.n208 VGND.n206 292.5
R798 VGND.n209 VGND.n208 292.5
R799 VGND.n930 VGND.n929 292.5
R800 VGND.n929 VGND.n928 292.5
R801 VGND.n199 VGND.n198 292.5
R802 VGND.n198 VGND.n197 292.5
R803 VGND.n939 VGND.n938 292.5
R804 VGND.n940 VGND.n939 292.5
R805 VGND.n392 VGND.n194 292.5
R806 VGND.n195 VGND.n194 292.5
R807 VGND.n946 VGND.n945 292.5
R808 VGND.n945 VGND.n944 292.5
R809 VGND.n193 VGND.n184 292.5
R810 VGND.n184 VGND.n183 292.5
R811 VGND.n955 VGND.n954 292.5
R812 VGND.n956 VGND.n955 292.5
R813 VGND.n186 VGND.n180 292.5
R814 VGND.n181 VGND.n180 292.5
R815 VGND.n962 VGND.n961 292.5
R816 VGND.n961 VGND.n960 292.5
R817 VGND.n179 VGND.n170 292.5
R818 VGND.n170 VGND.n169 292.5
R819 VGND.n971 VGND.n970 292.5
R820 VGND.n972 VGND.n971 292.5
R821 VGND.n172 VGND.n166 292.5
R822 VGND.n167 VGND.n166 292.5
R823 VGND.n978 VGND.n977 292.5
R824 VGND.n977 VGND.n976 292.5
R825 VGND.n165 VGND.n157 292.5
R826 VGND.n157 VGND.n156 292.5
R827 VGND.n986 VGND.t0 292.5
R828 VGND.n987 VGND.n986 292.5
R829 VGND.n153 VGND.n151 292.5
R830 VGND.n154 VGND.n153 292.5
R831 VGND.n993 VGND.n992 292.5
R832 VGND.n992 VGND.n991 292.5
R833 VGND.n144 VGND.n143 292.5
R834 VGND.n143 VGND.n142 292.5
R835 VGND.n1002 VGND.n1001 292.5
R836 VGND.n1003 VGND.n1002 292.5
R837 VGND.n139 VGND.n137 292.5
R838 VGND.n140 VGND.n139 292.5
R839 VGND.n1009 VGND.n1008 292.5
R840 VGND.n1008 VGND.n1007 292.5
R841 VGND.n130 VGND.n129 292.5
R842 VGND.n129 VGND.n128 292.5
R843 VGND.n1018 VGND.n1017 292.5
R844 VGND.n1019 VGND.n1018 292.5
R845 VGND.n413 VGND.n125 292.5
R846 VGND.n126 VGND.n125 292.5
R847 VGND.n1025 VGND.n1024 292.5
R848 VGND.n1024 VGND.n1023 292.5
R849 VGND.n124 VGND.n115 292.5
R850 VGND.n115 VGND.n114 292.5
R851 VGND.n1034 VGND.n1033 292.5
R852 VGND.n1035 VGND.n1034 292.5
R853 VGND.n117 VGND.n111 292.5
R854 VGND.n112 VGND.n111 292.5
R855 VGND.n1041 VGND.n1040 292.5
R856 VGND.n1040 VGND.n1039 292.5
R857 VGND.n110 VGND.n101 292.5
R858 VGND.n101 VGND.n100 292.5
R859 VGND.n1050 VGND.n1049 292.5
R860 VGND.n1051 VGND.n1050 292.5
R861 VGND.n103 VGND.n97 292.5
R862 VGND.n98 VGND.n97 292.5
R863 VGND.n1057 VGND.n1056 292.5
R864 VGND.n1056 VGND.n1055 292.5
R865 VGND.n89 VGND.n88 292.5
R866 VGND.n88 VGND.n87 292.5
R867 VGND.n1066 VGND.n1065 292.5
R868 VGND.n1067 VGND.n1066 292.5
R869 VGND.n84 VGND.n82 292.5
R870 VGND.n85 VGND.n84 292.5
R871 VGND.n1073 VGND.n1072 292.5
R872 VGND.n1072 VGND.n1071 292.5
R873 VGND.n75 VGND.n74 292.5
R874 VGND.n74 VGND.n73 292.5
R875 VGND.n1082 VGND.n1081 292.5
R876 VGND.n1083 VGND.n1082 292.5
R877 VGND.n70 VGND.n68 292.5
R878 VGND.n71 VGND.n70 292.5
R879 VGND.n1089 VGND.n1088 292.5
R880 VGND.n1088 VGND.n1087 292.5
R881 VGND.n431 VGND.n60 292.5
R882 VGND.n60 VGND.n59 292.5
R883 VGND.n1098 VGND.n1097 292.5
R884 VGND.n1099 VGND.n1098 292.5
R885 VGND.n62 VGND.n56 292.5
R886 VGND.n57 VGND.n56 292.5
R887 VGND.n1105 VGND.n1104 292.5
R888 VGND.n1104 VGND.n1103 292.5
R889 VGND.n55 VGND.n46 292.5
R890 VGND.n46 VGND.n45 292.5
R891 VGND.n1114 VGND.n1113 292.5
R892 VGND.n1115 VGND.n1114 292.5
R893 VGND.n48 VGND.n42 292.5
R894 VGND.n43 VGND.n42 292.5
R895 VGND.n1121 VGND.n1120 292.5
R896 VGND.n1120 VGND.n1119 292.5
R897 VGND.n41 VGND.n33 292.5
R898 VGND.n33 VGND.n32 292.5
R899 VGND.n1130 VGND.n1129 292.5
R900 VGND.n1131 VGND.n1130 292.5
R901 VGND.n28 VGND.n26 292.5
R902 VGND.n29 VGND.n28 292.5
R903 VGND.n1138 VGND.n1137 292.5
R904 VGND.n1137 VGND.n1136 292.5
R905 VGND.n19 VGND.n18 292.5
R906 VGND.n30 VGND.n18 292.5
R907 VGND.n1148 VGND.n1147 292.5
R908 VGND.n1148 VGND.n17 292.5
R909 VGND.n1149 VGND.n7 292.5
R910 VGND.n1150 VGND.n1149 292.5
R911 VGND.n1177 VGND.n9 292.5
R912 VGND.n13 VGND.n9 292.5
R913 VGND.n357 VGND.n303 231.493
R914 VGND.n354 VGND.n303 231.493
R915 VGND.n309 VGND.n303 231.493
R916 VGND.n1154 VGND.n8 231.493
R917 VGND.n1157 VGND.n8 231.493
R918 VGND.n1160 VGND.n8 231.493
R919 VGND.n1161 VGND.n8 231.493
R920 VGND.n810 VGND.n303 231.493
R921 VGND.n586 VGND.n303 231.493
R922 VGND.n799 VGND.n303 231.493
R923 VGND.n791 VGND.n303 231.493
R924 VGND.n594 VGND.n303 231.493
R925 VGND.n782 VGND.n303 231.493
R926 VGND.n779 VGND.n303 231.493
R927 VGND.n770 VGND.n303 231.493
R928 VGND.n604 VGND.n303 231.493
R929 VGND.n759 VGND.n303 231.493
R930 VGND.n751 VGND.n303 231.493
R931 VGND.n612 VGND.n303 231.493
R932 VGND.n740 VGND.n303 231.493
R933 VGND.n732 VGND.n303 231.493
R934 VGND.n730 VGND.n303 231.493
R935 VGND.n722 VGND.n303 231.493
R936 VGND.n719 VGND.n303 231.493
R937 VGND.n710 VGND.n303 231.493
R938 VGND.n708 VGND.n303 231.493
R939 VGND.n700 VGND.n303 231.493
R940 VGND.n633 VGND.n303 231.493
R941 VGND.n690 VGND.n303 231.493
R942 VGND.n681 VGND.n303 231.493
R943 VGND.n679 VGND.n303 231.493
R944 VGND.n671 VGND.n303 231.493
R945 VGND.n645 VGND.n303 231.493
R946 VGND.n661 VGND.n303 231.493
R947 VGND.n658 VGND.n303 231.493
R948 VGND.n650 VGND.n303 231.493
R949 VGND.n1149 VGND.n9 164.93
R950 VGND.n1149 VGND.n1148 164.93
R951 VGND.n1148 VGND.n18 164.93
R952 VGND.n1137 VGND.n18 164.93
R953 VGND.n1137 VGND.n28 164.93
R954 VGND.n1130 VGND.n28 164.93
R955 VGND.n1130 VGND.n33 164.93
R956 VGND.n1120 VGND.n33 164.93
R957 VGND.n1120 VGND.n42 164.93
R958 VGND.n1114 VGND.n42 164.93
R959 VGND.n1114 VGND.n46 164.93
R960 VGND.n1104 VGND.n46 164.93
R961 VGND.n1104 VGND.n56 164.93
R962 VGND.n1098 VGND.n56 164.93
R963 VGND.n1098 VGND.n60 164.93
R964 VGND.n1088 VGND.n60 164.93
R965 VGND.n1088 VGND.n70 164.93
R966 VGND.n1082 VGND.n70 164.93
R967 VGND.n1082 VGND.n74 164.93
R968 VGND.n1072 VGND.n74 164.93
R969 VGND.n1072 VGND.n84 164.93
R970 VGND.n1066 VGND.n84 164.93
R971 VGND.n1066 VGND.n88 164.93
R972 VGND.n1056 VGND.n88 164.93
R973 VGND.n1056 VGND.n97 164.93
R974 VGND.n1050 VGND.n97 164.93
R975 VGND.n1050 VGND.n101 164.93
R976 VGND.n1040 VGND.n101 164.93
R977 VGND.n1040 VGND.n111 164.93
R978 VGND.n1034 VGND.n111 164.93
R979 VGND.n1034 VGND.n115 164.93
R980 VGND.n1024 VGND.n115 164.93
R981 VGND.n1024 VGND.n125 164.93
R982 VGND.n1018 VGND.n125 164.93
R983 VGND.n1018 VGND.n129 164.93
R984 VGND.n1008 VGND.n129 164.93
R985 VGND.n1008 VGND.n139 164.93
R986 VGND.n1002 VGND.n139 164.93
R987 VGND.n1002 VGND.n143 164.93
R988 VGND.n992 VGND.n143 164.93
R989 VGND.n992 VGND.n153 164.93
R990 VGND.n986 VGND.n153 164.93
R991 VGND.n986 VGND.n157 164.93
R992 VGND.n977 VGND.n157 164.93
R993 VGND.n977 VGND.n166 164.93
R994 VGND.n971 VGND.n166 164.93
R995 VGND.n971 VGND.n170 164.93
R996 VGND.n961 VGND.n170 164.93
R997 VGND.n961 VGND.n180 164.93
R998 VGND.n955 VGND.n180 164.93
R999 VGND.n955 VGND.n184 164.93
R1000 VGND.n945 VGND.n184 164.93
R1001 VGND.n945 VGND.n194 164.93
R1002 VGND.n939 VGND.n194 164.93
R1003 VGND.n939 VGND.n198 164.93
R1004 VGND.n929 VGND.n198 164.93
R1005 VGND.n929 VGND.n208 164.93
R1006 VGND.n923 VGND.n208 164.93
R1007 VGND.n923 VGND.n212 164.93
R1008 VGND.n913 VGND.n212 164.93
R1009 VGND.n913 VGND.n222 164.93
R1010 VGND.n907 VGND.n222 164.93
R1011 VGND.n907 VGND.n226 164.93
R1012 VGND.n897 VGND.n226 164.93
R1013 VGND.n897 VGND.n235 164.93
R1014 VGND.n891 VGND.n235 164.93
R1015 VGND.n891 VGND.n239 164.93
R1016 VGND.n881 VGND.n239 164.93
R1017 VGND.n881 VGND.n249 164.93
R1018 VGND.n875 VGND.n249 164.93
R1019 VGND.n875 VGND.n253 164.93
R1020 VGND.n865 VGND.n253 164.93
R1021 VGND.n865 VGND.n263 164.93
R1022 VGND.n859 VGND.n263 164.93
R1023 VGND.n859 VGND.n267 164.93
R1024 VGND.n849 VGND.n267 164.93
R1025 VGND.n849 VGND.n277 164.93
R1026 VGND.n843 VGND.n277 164.93
R1027 VGND.n843 VGND.n281 164.93
R1028 VGND.n833 VGND.n281 164.93
R1029 VGND.n833 VGND.n291 164.93
R1030 VGND.n827 VGND.n291 164.93
R1031 VGND.n827 VGND.n295 164.93
R1032 VGND.n817 VGND.n295 164.93
R1033 VGND.n11 VGND.n9 155.768
R1034 VGND.n817 VGND.n305 155.768
R1035 VGND.n0 VGND.t2 131.321
R1036 VGND.n351 VGND.t80 131.321
R1037 VGND.n358 VGND.n357 122.017
R1038 VGND.n354 VGND.n353 122.017
R1039 VGND.n310 VGND.n309 122.017
R1040 VGND.n1154 VGND.n14 122.017
R1041 VGND.n1157 VGND.n1156 122.017
R1042 VGND.n1160 VGND.n1159 122.017
R1043 VGND.n1162 VGND.n1161 122.017
R1044 VGND.n1161 VGND.n4 122.017
R1045 VGND.n1163 VGND.n1160 122.017
R1046 VGND.n1158 VGND.n1157 122.017
R1047 VGND.n1155 VGND.n1154 122.017
R1048 VGND.n810 VGND.n809 122.017
R1049 VGND.n801 VGND.n586 122.017
R1050 VGND.n799 VGND.n798 122.017
R1051 VGND.n792 VGND.n791 122.017
R1052 VGND.n598 VGND.n594 122.017
R1053 VGND.n783 VGND.n782 122.017
R1054 VGND.n780 VGND.n779 122.017
R1055 VGND.n771 VGND.n770 122.017
R1056 VGND.n761 VGND.n604 122.017
R1057 VGND.n759 VGND.n758 122.017
R1058 VGND.n751 VGND.n750 122.017
R1059 VGND.n742 VGND.n612 122.017
R1060 VGND.n741 VGND.n740 122.017
R1061 VGND.n733 VGND.n732 122.017
R1062 VGND.n731 VGND.n730 122.017
R1063 VGND.n723 VGND.n722 122.017
R1064 VGND.n720 VGND.n719 122.017
R1065 VGND.n711 VGND.n710 122.017
R1066 VGND.n708 VGND.n707 122.017
R1067 VGND.n701 VGND.n700 122.017
R1068 VGND.n691 VGND.n633 122.017
R1069 VGND.n690 VGND.n689 122.017
R1070 VGND.n682 VGND.n681 122.017
R1071 VGND.n679 VGND.n678 122.017
R1072 VGND.n672 VGND.n671 122.017
R1073 VGND.n662 VGND.n645 122.017
R1074 VGND.n661 VGND.n660 122.017
R1075 VGND.n659 VGND.n658 122.017
R1076 VGND.n650 VGND.n302 122.017
R1077 VGND.n811 VGND.n810 122.017
R1078 VGND.n808 VGND.n586 122.017
R1079 VGND.n800 VGND.n799 122.017
R1080 VGND.n791 VGND.n590 122.017
R1081 VGND.n789 VGND.n594 122.017
R1082 VGND.n782 VGND.n781 122.017
R1083 VGND.n779 VGND.n778 122.017
R1084 VGND.n770 VGND.n600 122.017
R1085 VGND.n768 VGND.n604 122.017
R1086 VGND.n760 VGND.n759 122.017
R1087 VGND.n752 VGND.n751 122.017
R1088 VGND.n749 VGND.n612 122.017
R1089 VGND.n740 VGND.n739 122.017
R1090 VGND.n732 VGND.n616 122.017
R1091 VGND.n730 VGND.n729 122.017
R1092 VGND.n722 VGND.n620 122.017
R1093 VGND.n719 VGND.n718 122.017
R1094 VGND.n710 VGND.n625 122.017
R1095 VGND.n709 VGND.n708 122.017
R1096 VGND.n700 VGND.n629 122.017
R1097 VGND.n698 VGND.n633 122.017
R1098 VGND.n692 VGND.n690 122.017
R1099 VGND.n681 VGND.n637 122.017
R1100 VGND.n680 VGND.n679 122.017
R1101 VGND.n671 VGND.n641 122.017
R1102 VGND.n669 VGND.n645 122.017
R1103 VGND.n663 VGND.n661 122.017
R1104 VGND.n658 VGND.n657 122.017
R1105 VGND.n651 VGND.n650 122.017
R1106 VGND.n357 VGND.n356 122.017
R1107 VGND.n355 VGND.n354 122.017
R1108 VGND.n309 VGND.n308 122.017
R1109 VGND.n314 VGND.n313 101.322
R1110 VGND.n316 VGND.n315 101.322
R1111 VGND.n318 VGND.n317 101.322
R1112 VGND.n320 VGND.n319 101.322
R1113 VGND.n322 VGND.n321 101.322
R1114 VGND.n324 VGND.n323 101.322
R1115 VGND.n326 VGND.n325 101.322
R1116 VGND.n328 VGND.n327 101.322
R1117 VGND.n330 VGND.n329 101.322
R1118 VGND.n332 VGND.n331 101.322
R1119 VGND.n334 VGND.n333 101.322
R1120 VGND.n336 VGND.n335 101.322
R1121 VGND.n338 VGND.n337 101.322
R1122 VGND.n340 VGND.n339 101.322
R1123 VGND.n342 VGND.n341 101.322
R1124 VGND.n344 VGND.n343 101.322
R1125 VGND.n346 VGND.n345 101.322
R1126 VGND.n348 VGND.n347 101.322
R1127 VGND.n350 VGND.n349 101.322
R1128 VGND.n1177 VGND.n7 53.2621
R1129 VGND.n1147 VGND.n7 53.2621
R1130 VGND.n1147 VGND.n19 53.2621
R1131 VGND.n1138 VGND.n19 53.2621
R1132 VGND.n1138 VGND.n26 53.2621
R1133 VGND.n1129 VGND.n26 53.2621
R1134 VGND.n1121 VGND.n41 53.2621
R1135 VGND.n1113 VGND.n48 53.2621
R1136 VGND.n1105 VGND.n55 53.2621
R1137 VGND.n1097 VGND.n62 53.2621
R1138 VGND.n1089 VGND.n68 53.2621
R1139 VGND.n1081 VGND.n75 53.2621
R1140 VGND.n1073 VGND.n82 53.2621
R1141 VGND.n1065 VGND.n89 53.2621
R1142 VGND.n1049 VGND.n103 53.2621
R1143 VGND.n1041 VGND.n110 53.2621
R1144 VGND.n1033 VGND.n117 53.2621
R1145 VGND.n1025 VGND.n124 53.2621
R1146 VGND.n1017 VGND.n130 53.2621
R1147 VGND.n1009 VGND.n137 53.2621
R1148 VGND.n1001 VGND.n144 53.2621
R1149 VGND.n993 VGND.n151 53.2621
R1150 VGND.n978 VGND.n165 53.2621
R1151 VGND.n970 VGND.n172 53.2621
R1152 VGND.n962 VGND.n179 53.2621
R1153 VGND.n954 VGND.n186 53.2621
R1154 VGND.n946 VGND.n193 53.2621
R1155 VGND.n938 VGND.n199 53.2621
R1156 VGND.n930 VGND.n206 53.2621
R1157 VGND.n922 VGND.n213 53.2621
R1158 VGND.n914 VGND.n220 53.2621
R1159 VGND.n898 VGND.n234 53.2621
R1160 VGND.n890 VGND.n241 53.2621
R1161 VGND.n882 VGND.n248 53.2621
R1162 VGND.n874 VGND.n255 53.2621
R1163 VGND.n866 VGND.n261 53.2621
R1164 VGND.n858 VGND.n268 53.2621
R1165 VGND.n850 VGND.n275 53.2621
R1166 VGND.n842 VGND.n282 53.2621
R1167 VGND.n834 VGND.n282 53.2621
R1168 VGND.n834 VGND.n289 53.2621
R1169 VGND.n826 VGND.n289 53.2621
R1170 VGND.n826 VGND.n296 53.2621
R1171 VGND.n818 VGND.n296 53.2621
R1172 VGND.t0 VGND.t41 52.5224
R1173 VGND.n392 VGND.t51 52.5224
R1174 VGND.n413 VGND.t31 51.0429
R1175 VGND.n906 VGND.t61 51.0429
R1176 VGND.n1177 VGND.n8 50.3031
R1177 VGND.n818 VGND.n303 50.3031
R1178 VGND.n1057 VGND.t21 49.5634
R1179 VGND.n372 VGND.t71 49.5634
R1180 VGND.n820 VGND.n301 48.6961
R1181 VGND.n431 VGND.t9 48.0839
R1182 VGND.n431 VGND.t11 48.0839
R1183 VGND.n1129 VGND.t1 46.6044
R1184 VGND.n1057 VGND.t19 46.6044
R1185 VGND.n372 VGND.t73 46.6044
R1186 VGND.n413 VGND.t29 45.1249
R1187 VGND.n906 VGND.t63 45.1249
R1188 VGND.t0 VGND.t39 43.6454
R1189 VGND.n392 VGND.t53 43.6454
R1190 VGND.n572 VGND.n571 43.4092
R1191 VGND.n1180 VGND.n1179 43.4092
R1192 VGND.n978 VGND.t43 42.1659
R1193 VGND.n193 VGND.t49 42.1659
R1194 VGND.t33 VGND.n130 40.6864
R1195 VGND.n914 VGND.t59 40.6864
R1196 VGND.n1049 VGND.t23 39.207
R1197 VGND.n255 VGND.t69 39.207
R1198 VGND.n62 VGND.t7 37.7275
R1199 VGND.t13 VGND.n68 37.7275
R1200 VGND.n842 VGND.t79 37.7275
R1201 VGND.n1121 VGND.t3 36.248
R1202 VGND.n1065 VGND.t17 36.248
R1203 VGND.t75 VGND.n261 36.248
R1204 VGND.n124 VGND.t27 34.7685
R1205 VGND.n898 VGND.t65 34.7685
R1206 VGND.n993 VGND.t37 33.289
R1207 VGND.t55 VGND.n199 33.289
R1208 VGND.n970 VGND.t45 31.8095
R1209 VGND.n186 VGND.t47 31.8095
R1210 VGND.t35 VGND.n137 30.33
R1211 VGND.n922 VGND.t57 30.33
R1212 VGND.n349 VGND.t76 30.0005
R1213 VGND.n349 VGND.t78 30.0005
R1214 VGND.n347 VGND.t72 30.0005
R1215 VGND.n347 VGND.t74 30.0005
R1216 VGND.n345 VGND.t68 30.0005
R1217 VGND.n345 VGND.t70 30.0005
R1218 VGND.n343 VGND.t64 30.0005
R1219 VGND.n343 VGND.t66 30.0005
R1220 VGND.n341 VGND.t60 30.0005
R1221 VGND.n341 VGND.t62 30.0005
R1222 VGND.n339 VGND.t56 30.0005
R1223 VGND.n339 VGND.t58 30.0005
R1224 VGND.n337 VGND.t52 30.0005
R1225 VGND.n337 VGND.t54 30.0005
R1226 VGND.n335 VGND.t48 30.0005
R1227 VGND.n335 VGND.t50 30.0005
R1228 VGND.n333 VGND.t44 30.0005
R1229 VGND.n333 VGND.t46 30.0005
R1230 VGND.n331 VGND.t40 30.0005
R1231 VGND.n331 VGND.t42 30.0005
R1232 VGND.n329 VGND.t36 30.0005
R1233 VGND.n329 VGND.t38 30.0005
R1234 VGND.n327 VGND.t32 30.0005
R1235 VGND.n327 VGND.t34 30.0005
R1236 VGND.n325 VGND.t28 30.0005
R1237 VGND.n325 VGND.t30 30.0005
R1238 VGND.n323 VGND.t24 30.0005
R1239 VGND.n323 VGND.t26 30.0005
R1240 VGND.n321 VGND.t20 30.0005
R1241 VGND.n321 VGND.t22 30.0005
R1242 VGND.n319 VGND.t16 30.0005
R1243 VGND.n319 VGND.t18 30.0005
R1244 VGND.n317 VGND.t12 30.0005
R1245 VGND.n317 VGND.t14 30.0005
R1246 VGND.n315 VGND.t8 30.0005
R1247 VGND.n315 VGND.t10 30.0005
R1248 VGND.n313 VGND.t4 30.0005
R1249 VGND.n313 VGND.t6 30.0005
R1250 VGND.n812 VGND.n306 29.7744
R1251 VGND.n1041 VGND.t25 28.8505
R1252 VGND.n248 VGND.t67 28.8505
R1253 VGND.n55 VGND.t5 27.371
R1254 VGND.t15 VGND.n75 27.371
R1255 VGND.n850 VGND.t77 27.371
R1256 VGND.n1113 VGND.t5 25.8916
R1257 VGND.n1073 VGND.t15 25.8916
R1258 VGND.t77 VGND.n268 25.8916
R1259 VGND.n582 VGND.n306 24.4875
R1260 VGND.n1174 VGND.n1173 24.4875
R1261 VGND.n117 VGND.t25 24.4121
R1262 VGND.n890 VGND.t67 24.4121
R1263 VGND.n1001 VGND.t35 22.9326
R1264 VGND.t57 VGND.n206 22.9326
R1265 VGND.n179 VGND.t45 21.4531
R1266 VGND.n962 VGND.t47 21.4531
R1267 VGND.n573 VGND.n572 20.0353
R1268 VGND.n576 VGND.n575 20.0353
R1269 VGND.n576 VGND.n312 20.0353
R1270 VGND.n580 VGND.n312 20.0353
R1271 VGND.n581 VGND.n580 20.0353
R1272 VGND.n582 VGND.n581 20.0353
R1273 VGND.n1179 VGND.n5 20.0353
R1274 VGND.n447 VGND.n5 20.0353
R1275 VGND.n447 VGND.n445 20.0353
R1276 VGND.n451 VGND.n445 20.0353
R1277 VGND.n452 VGND.n451 20.0353
R1278 VGND.n453 VGND.n452 20.0353
R1279 VGND.n453 VGND.n441 20.0353
R1280 VGND.n457 VGND.n441 20.0353
R1281 VGND.n458 VGND.n457 20.0353
R1282 VGND.n459 VGND.n458 20.0353
R1283 VGND.n459 VGND.n437 20.0353
R1284 VGND.n463 VGND.n437 20.0353
R1285 VGND.n464 VGND.n463 20.0353
R1286 VGND.n465 VGND.n464 20.0353
R1287 VGND.n465 VGND.n433 20.0353
R1288 VGND.n469 VGND.n433 20.0353
R1289 VGND.n470 VGND.n469 20.0353
R1290 VGND.n471 VGND.n470 20.0353
R1291 VGND.n471 VGND.n428 20.0353
R1292 VGND.n475 VGND.n428 20.0353
R1293 VGND.n476 VGND.n475 20.0353
R1294 VGND.n477 VGND.n476 20.0353
R1295 VGND.n477 VGND.n424 20.0353
R1296 VGND.n481 VGND.n424 20.0353
R1297 VGND.n482 VGND.n481 20.0353
R1298 VGND.n483 VGND.n482 20.0353
R1299 VGND.n483 VGND.n420 20.0353
R1300 VGND.n487 VGND.n420 20.0353
R1301 VGND.n488 VGND.n487 20.0353
R1302 VGND.n489 VGND.n488 20.0353
R1303 VGND.n489 VGND.n416 20.0353
R1304 VGND.n493 VGND.n416 20.0353
R1305 VGND.n494 VGND.n493 20.0353
R1306 VGND.n495 VGND.n494 20.0353
R1307 VGND.n495 VGND.n411 20.0353
R1308 VGND.n499 VGND.n411 20.0353
R1309 VGND.n500 VGND.n499 20.0353
R1310 VGND.n501 VGND.n500 20.0353
R1311 VGND.n501 VGND.n407 20.0353
R1312 VGND.n505 VGND.n407 20.0353
R1313 VGND.n506 VGND.n505 20.0353
R1314 VGND.n507 VGND.n506 20.0353
R1315 VGND.n507 VGND.n403 20.0353
R1316 VGND.n511 VGND.n403 20.0353
R1317 VGND.n512 VGND.n511 20.0353
R1318 VGND.n513 VGND.n512 20.0353
R1319 VGND.n513 VGND.n399 20.0353
R1320 VGND.n517 VGND.n399 20.0353
R1321 VGND.n518 VGND.n517 20.0353
R1322 VGND.n519 VGND.n518 20.0353
R1323 VGND.n519 VGND.n395 20.0353
R1324 VGND.n523 VGND.n395 20.0353
R1325 VGND.n524 VGND.n523 20.0353
R1326 VGND.n525 VGND.n524 20.0353
R1327 VGND.n525 VGND.n390 20.0353
R1328 VGND.n529 VGND.n390 20.0353
R1329 VGND.n530 VGND.n529 20.0353
R1330 VGND.n531 VGND.n530 20.0353
R1331 VGND.n531 VGND.n386 20.0353
R1332 VGND.n535 VGND.n386 20.0353
R1333 VGND.n536 VGND.n535 20.0353
R1334 VGND.n537 VGND.n536 20.0353
R1335 VGND.n537 VGND.n382 20.0353
R1336 VGND.n541 VGND.n382 20.0353
R1337 VGND.n542 VGND.n541 20.0353
R1338 VGND.n543 VGND.n542 20.0353
R1339 VGND.n543 VGND.n378 20.0353
R1340 VGND.n547 VGND.n378 20.0353
R1341 VGND.n548 VGND.n547 20.0353
R1342 VGND.n549 VGND.n548 20.0353
R1343 VGND.n549 VGND.n374 20.0353
R1344 VGND.n553 VGND.n374 20.0353
R1345 VGND.n554 VGND.n553 20.0353
R1346 VGND.n555 VGND.n554 20.0353
R1347 VGND.n555 VGND.n369 20.0353
R1348 VGND.n559 VGND.n369 20.0353
R1349 VGND.n560 VGND.n559 20.0353
R1350 VGND.n561 VGND.n560 20.0353
R1351 VGND.n561 VGND.n365 20.0353
R1352 VGND.n565 VGND.n365 20.0353
R1353 VGND.n566 VGND.n565 20.0353
R1354 VGND.n567 VGND.n566 20.0353
R1355 VGND.n567 VGND.n361 20.0353
R1356 VGND.n571 VGND.n361 20.0353
R1357 VGND.n1180 VGND.n3 20.0353
R1358 VGND.n1164 VGND.n3 20.0353
R1359 VGND.n1167 VGND.n1164 20.0353
R1360 VGND.n1168 VGND.n1167 20.0353
R1361 VGND.n1169 VGND.n1168 20.0353
R1362 VGND.n1169 VGND.n15 20.0353
R1363 VGND.n1173 VGND.n15 20.0353
R1364 VGND.n812 VGND.n585 20.0353
R1365 VGND.n807 VGND.n585 20.0353
R1366 VGND.n807 VGND.n587 20.0353
R1367 VGND.n803 VGND.n587 20.0353
R1368 VGND.n803 VGND.n589 20.0353
R1369 VGND.n797 VGND.n589 20.0353
R1370 VGND.n797 VGND.n591 20.0353
R1371 VGND.n793 VGND.n591 20.0353
R1372 VGND.n793 VGND.n593 20.0353
R1373 VGND.n788 VGND.n593 20.0353
R1374 VGND.n788 VGND.n595 20.0353
R1375 VGND.n784 VGND.n595 20.0353
R1376 VGND.n784 VGND.n597 20.0353
R1377 VGND.n599 VGND.n597 20.0353
R1378 VGND.n777 VGND.n599 20.0353
R1379 VGND.n777 VGND.n601 20.0353
R1380 VGND.n772 VGND.n601 20.0353
R1381 VGND.n772 VGND.n603 20.0353
R1382 VGND.n767 VGND.n603 20.0353
R1383 VGND.n767 VGND.n605 20.0353
R1384 VGND.n763 VGND.n605 20.0353
R1385 VGND.n763 VGND.n607 20.0353
R1386 VGND.n757 VGND.n607 20.0353
R1387 VGND.n757 VGND.n609 20.0353
R1388 VGND.n753 VGND.n609 20.0353
R1389 VGND.n753 VGND.n611 20.0353
R1390 VGND.n748 VGND.n611 20.0353
R1391 VGND.n748 VGND.n613 20.0353
R1392 VGND.n744 VGND.n613 20.0353
R1393 VGND.n744 VGND.n615 20.0353
R1394 VGND.n738 VGND.n615 20.0353
R1395 VGND.n738 VGND.n617 20.0353
R1396 VGND.n734 VGND.n617 20.0353
R1397 VGND.n734 VGND.n619 20.0353
R1398 VGND.n728 VGND.n619 20.0353
R1399 VGND.n728 VGND.n621 20.0353
R1400 VGND.n724 VGND.n621 20.0353
R1401 VGND.n724 VGND.n623 20.0353
R1402 VGND.n624 VGND.n623 20.0353
R1403 VGND.n717 VGND.n624 20.0353
R1404 VGND.n717 VGND.n626 20.0353
R1405 VGND.n712 VGND.n626 20.0353
R1406 VGND.n712 VGND.n628 20.0353
R1407 VGND.n706 VGND.n628 20.0353
R1408 VGND.n706 VGND.n630 20.0353
R1409 VGND.n702 VGND.n630 20.0353
R1410 VGND.n702 VGND.n632 20.0353
R1411 VGND.n697 VGND.n632 20.0353
R1412 VGND.n697 VGND.n634 20.0353
R1413 VGND.n693 VGND.n634 20.0353
R1414 VGND.n693 VGND.n636 20.0353
R1415 VGND.n687 VGND.n636 20.0353
R1416 VGND.n687 VGND.n638 20.0353
R1417 VGND.n683 VGND.n638 20.0353
R1418 VGND.n683 VGND.n640 20.0353
R1419 VGND.n677 VGND.n640 20.0353
R1420 VGND.n677 VGND.n642 20.0353
R1421 VGND.n673 VGND.n642 20.0353
R1422 VGND.n673 VGND.n644 20.0353
R1423 VGND.n668 VGND.n644 20.0353
R1424 VGND.n668 VGND.n646 20.0353
R1425 VGND.n664 VGND.n646 20.0353
R1426 VGND.n664 VGND.n648 20.0353
R1427 VGND.n649 VGND.n648 20.0353
R1428 VGND.n656 VGND.n649 20.0353
R1429 VGND.n656 VGND.n652 20.0353
R1430 VGND.n652 VGND.n301 20.0353
R1431 VGND.n1145 VGND.n1144 20.0353
R1432 VGND.n1145 VGND.n22 20.0353
R1433 VGND.n1140 VGND.n22 20.0353
R1434 VGND.n1140 VGND.n24 20.0353
R1435 VGND.n1127 VGND.n24 20.0353
R1436 VGND.n1127 VGND.n36 20.0353
R1437 VGND.n1123 VGND.n36 20.0353
R1438 VGND.n1123 VGND.n38 20.0353
R1439 VGND.n1111 VGND.n38 20.0353
R1440 VGND.n1111 VGND.n50 20.0353
R1441 VGND.n1107 VGND.n50 20.0353
R1442 VGND.n1107 VGND.n52 20.0353
R1443 VGND.n1095 VGND.n52 20.0353
R1444 VGND.n1095 VGND.n64 20.0353
R1445 VGND.n1091 VGND.n64 20.0353
R1446 VGND.n1091 VGND.n66 20.0353
R1447 VGND.n1079 VGND.n66 20.0353
R1448 VGND.n1079 VGND.n78 20.0353
R1449 VGND.n1075 VGND.n78 20.0353
R1450 VGND.n1075 VGND.n80 20.0353
R1451 VGND.n1063 VGND.n80 20.0353
R1452 VGND.n1063 VGND.n92 20.0353
R1453 VGND.n1059 VGND.n92 20.0353
R1454 VGND.n1059 VGND.n94 20.0353
R1455 VGND.n1047 VGND.n94 20.0353
R1456 VGND.n1047 VGND.n105 20.0353
R1457 VGND.n1043 VGND.n105 20.0353
R1458 VGND.n1043 VGND.n107 20.0353
R1459 VGND.n1031 VGND.n107 20.0353
R1460 VGND.n1031 VGND.n119 20.0353
R1461 VGND.n1027 VGND.n119 20.0353
R1462 VGND.n1027 VGND.n121 20.0353
R1463 VGND.n1015 VGND.n121 20.0353
R1464 VGND.n1015 VGND.n133 20.0353
R1465 VGND.n1011 VGND.n133 20.0353
R1466 VGND.n1011 VGND.n135 20.0353
R1467 VGND.n999 VGND.n135 20.0353
R1468 VGND.n999 VGND.n147 20.0353
R1469 VGND.n995 VGND.n147 20.0353
R1470 VGND.n995 VGND.n149 20.0353
R1471 VGND.n984 VGND.n149 20.0353
R1472 VGND.n984 VGND.n160 20.0353
R1473 VGND.n980 VGND.n160 20.0353
R1474 VGND.n980 VGND.n162 20.0353
R1475 VGND.n968 VGND.n162 20.0353
R1476 VGND.n968 VGND.n174 20.0353
R1477 VGND.n964 VGND.n174 20.0353
R1478 VGND.n964 VGND.n176 20.0353
R1479 VGND.n952 VGND.n176 20.0353
R1480 VGND.n952 VGND.n188 20.0353
R1481 VGND.n948 VGND.n188 20.0353
R1482 VGND.n948 VGND.n190 20.0353
R1483 VGND.n936 VGND.n190 20.0353
R1484 VGND.n936 VGND.n202 20.0353
R1485 VGND.n932 VGND.n202 20.0353
R1486 VGND.n932 VGND.n204 20.0353
R1487 VGND.n920 VGND.n204 20.0353
R1488 VGND.n920 VGND.n216 20.0353
R1489 VGND.n916 VGND.n216 20.0353
R1490 VGND.n916 VGND.n218 20.0353
R1491 VGND.n904 VGND.n218 20.0353
R1492 VGND.n904 VGND.n229 20.0353
R1493 VGND.n900 VGND.n229 20.0353
R1494 VGND.n900 VGND.n231 20.0353
R1495 VGND.n888 VGND.n231 20.0353
R1496 VGND.n888 VGND.n243 20.0353
R1497 VGND.n884 VGND.n243 20.0353
R1498 VGND.n884 VGND.n245 20.0353
R1499 VGND.n872 VGND.n245 20.0353
R1500 VGND.n872 VGND.n257 20.0353
R1501 VGND.n868 VGND.n257 20.0353
R1502 VGND.n868 VGND.n259 20.0353
R1503 VGND.n856 VGND.n259 20.0353
R1504 VGND.n856 VGND.n271 20.0353
R1505 VGND.n852 VGND.n271 20.0353
R1506 VGND.n852 VGND.n273 20.0353
R1507 VGND.n840 VGND.n273 20.0353
R1508 VGND.n840 VGND.n285 20.0353
R1509 VGND.n836 VGND.n285 20.0353
R1510 VGND.n836 VGND.n287 20.0353
R1511 VGND.n824 VGND.n287 20.0353
R1512 VGND.n824 VGND.n299 20.0353
R1513 VGND.n820 VGND.n299 20.0353
R1514 VGND.t37 VGND.n144 19.9736
R1515 VGND.n930 VGND.t55 19.9736
R1516 VGND.n1033 VGND.t27 18.4941
R1517 VGND.n241 VGND.t65 18.4941
R1518 VGND.n48 VGND.t3 17.0146
R1519 VGND.t17 VGND.n82 17.0146
R1520 VGND.n858 VGND.t75 17.0146
R1521 VGND.n1105 VGND.t7 15.5351
R1522 VGND.n1081 VGND.t13 15.5351
R1523 VGND.t79 VGND.n275 15.5351
R1524 VGND.n110 VGND.t23 14.0556
R1525 VGND.n882 VGND.t69 14.0556
R1526 VGND.n1009 VGND.t33 12.5762
R1527 VGND.t59 VGND.n213 12.5762
R1528 VGND.n172 VGND.t43 11.0967
R1529 VGND.n954 VGND.t49 11.0967
R1530 VGND.n1150 VGND.n13 10.7168
R1531 VGND.n1150 VGND.n17 10.7168
R1532 VGND.n30 VGND.n17 10.7168
R1533 VGND.n1136 VGND.n30 10.7168
R1534 VGND.n1136 VGND.n29 10.7168
R1535 VGND.n1131 VGND.n29 10.7168
R1536 VGND.n1131 VGND.n32 10.7168
R1537 VGND.n1119 VGND.n32 10.7168
R1538 VGND.n1119 VGND.n43 10.7168
R1539 VGND.n1115 VGND.n43 10.7168
R1540 VGND.n1115 VGND.n45 10.7168
R1541 VGND.n1103 VGND.n45 10.7168
R1542 VGND.n1103 VGND.n57 10.7168
R1543 VGND.n1099 VGND.n57 10.7168
R1544 VGND.n1099 VGND.n59 10.7168
R1545 VGND.n1087 VGND.n59 10.7168
R1546 VGND.n1087 VGND.n71 10.7168
R1547 VGND.n1083 VGND.n71 10.7168
R1548 VGND.n1083 VGND.n73 10.7168
R1549 VGND.n1071 VGND.n73 10.7168
R1550 VGND.n1071 VGND.n85 10.7168
R1551 VGND.n1067 VGND.n85 10.7168
R1552 VGND.n1067 VGND.n87 10.7168
R1553 VGND.n1055 VGND.n87 10.7168
R1554 VGND.n1055 VGND.n98 10.7168
R1555 VGND.n1051 VGND.n98 10.7168
R1556 VGND.n1051 VGND.n100 10.7168
R1557 VGND.n1039 VGND.n100 10.7168
R1558 VGND.n1039 VGND.n112 10.7168
R1559 VGND.n1035 VGND.n112 10.7168
R1560 VGND.n1035 VGND.n114 10.7168
R1561 VGND.n1023 VGND.n114 10.7168
R1562 VGND.n1023 VGND.n126 10.7168
R1563 VGND.n1019 VGND.n126 10.7168
R1564 VGND.n1019 VGND.n128 10.7168
R1565 VGND.n1007 VGND.n128 10.7168
R1566 VGND.n1007 VGND.n140 10.7168
R1567 VGND.n1003 VGND.n140 10.7168
R1568 VGND.n1003 VGND.n142 10.7168
R1569 VGND.n991 VGND.n142 10.7168
R1570 VGND.n991 VGND.n154 10.7168
R1571 VGND.n987 VGND.n154 10.7168
R1572 VGND.n987 VGND.n156 10.7168
R1573 VGND.n976 VGND.n156 10.7168
R1574 VGND.n976 VGND.n167 10.7168
R1575 VGND.n972 VGND.n167 10.7168
R1576 VGND.n972 VGND.n169 10.7168
R1577 VGND.n960 VGND.n169 10.7168
R1578 VGND.n960 VGND.n181 10.7168
R1579 VGND.n956 VGND.n181 10.7168
R1580 VGND.n956 VGND.n183 10.7168
R1581 VGND.n944 VGND.n183 10.7168
R1582 VGND.n944 VGND.n195 10.7168
R1583 VGND.n940 VGND.n195 10.7168
R1584 VGND.n940 VGND.n197 10.7168
R1585 VGND.n928 VGND.n197 10.7168
R1586 VGND.n928 VGND.n209 10.7168
R1587 VGND.n924 VGND.n209 10.7168
R1588 VGND.n924 VGND.n211 10.7168
R1589 VGND.n912 VGND.n211 10.7168
R1590 VGND.n912 VGND.n223 10.7168
R1591 VGND.n908 VGND.n223 10.7168
R1592 VGND.n908 VGND.n225 10.7168
R1593 VGND.n896 VGND.n225 10.7168
R1594 VGND.n896 VGND.n236 10.7168
R1595 VGND.n892 VGND.n236 10.7168
R1596 VGND.n892 VGND.n238 10.7168
R1597 VGND.n880 VGND.n238 10.7168
R1598 VGND.n880 VGND.n250 10.7168
R1599 VGND.n876 VGND.n250 10.7168
R1600 VGND.n876 VGND.n252 10.7168
R1601 VGND.n864 VGND.n252 10.7168
R1602 VGND.n864 VGND.n264 10.7168
R1603 VGND.n860 VGND.n264 10.7168
R1604 VGND.n860 VGND.n266 10.7168
R1605 VGND.n848 VGND.n266 10.7168
R1606 VGND.n848 VGND.n278 10.7168
R1607 VGND.n844 VGND.n278 10.7168
R1608 VGND.n844 VGND.n280 10.7168
R1609 VGND.n832 VGND.n280 10.7168
R1610 VGND.n832 VGND.n292 10.7168
R1611 VGND.n828 VGND.n292 10.7168
R1612 VGND.n828 VGND.n294 10.7168
R1613 VGND.n816 VGND.n294 10.7168
R1614 VGND.n1174 VGND.n13 10.1214
R1615 VGND.n816 VGND.n306 10.1214
R1616 VGND.t39 VGND.n151 9.61718
R1617 VGND.n938 VGND.t53 9.61718
R1618 VGND.n1165 VGND.n1164 9.3005
R1619 VGND.n3 VGND.n1 9.3005
R1620 VGND.n1181 VGND.n1180 9.3005
R1621 VGND.n571 VGND.n570 9.3005
R1622 VGND.n569 VGND.n361 9.3005
R1623 VGND.n568 VGND.n567 9.3005
R1624 VGND.n566 VGND.n362 9.3005
R1625 VGND.n565 VGND.n564 9.3005
R1626 VGND.n563 VGND.n365 9.3005
R1627 VGND.n562 VGND.n561 9.3005
R1628 VGND.n560 VGND.n366 9.3005
R1629 VGND.n559 VGND.n558 9.3005
R1630 VGND.n557 VGND.n369 9.3005
R1631 VGND.n556 VGND.n555 9.3005
R1632 VGND.n554 VGND.n370 9.3005
R1633 VGND.n553 VGND.n552 9.3005
R1634 VGND.n551 VGND.n374 9.3005
R1635 VGND.n550 VGND.n549 9.3005
R1636 VGND.n548 VGND.n375 9.3005
R1637 VGND.n547 VGND.n546 9.3005
R1638 VGND.n545 VGND.n378 9.3005
R1639 VGND.n544 VGND.n543 9.3005
R1640 VGND.n542 VGND.n379 9.3005
R1641 VGND.n541 VGND.n540 9.3005
R1642 VGND.n539 VGND.n382 9.3005
R1643 VGND.n538 VGND.n537 9.3005
R1644 VGND.n536 VGND.n383 9.3005
R1645 VGND.n535 VGND.n534 9.3005
R1646 VGND.n533 VGND.n386 9.3005
R1647 VGND.n532 VGND.n531 9.3005
R1648 VGND.n530 VGND.n387 9.3005
R1649 VGND.n529 VGND.n528 9.3005
R1650 VGND.n527 VGND.n390 9.3005
R1651 VGND.n526 VGND.n525 9.3005
R1652 VGND.n524 VGND.n391 9.3005
R1653 VGND.n523 VGND.n522 9.3005
R1654 VGND.n521 VGND.n395 9.3005
R1655 VGND.n520 VGND.n519 9.3005
R1656 VGND.n518 VGND.n396 9.3005
R1657 VGND.n517 VGND.n516 9.3005
R1658 VGND.n515 VGND.n399 9.3005
R1659 VGND.n514 VGND.n513 9.3005
R1660 VGND.n512 VGND.n400 9.3005
R1661 VGND.n511 VGND.n510 9.3005
R1662 VGND.n509 VGND.n403 9.3005
R1663 VGND.n508 VGND.n507 9.3005
R1664 VGND.n506 VGND.n404 9.3005
R1665 VGND.n505 VGND.n504 9.3005
R1666 VGND.n503 VGND.n407 9.3005
R1667 VGND.n502 VGND.n501 9.3005
R1668 VGND.n500 VGND.n408 9.3005
R1669 VGND.n499 VGND.n498 9.3005
R1670 VGND.n497 VGND.n411 9.3005
R1671 VGND.n496 VGND.n495 9.3005
R1672 VGND.n494 VGND.n412 9.3005
R1673 VGND.n493 VGND.n492 9.3005
R1674 VGND.n491 VGND.n416 9.3005
R1675 VGND.n490 VGND.n489 9.3005
R1676 VGND.n488 VGND.n417 9.3005
R1677 VGND.n487 VGND.n486 9.3005
R1678 VGND.n485 VGND.n420 9.3005
R1679 VGND.n484 VGND.n483 9.3005
R1680 VGND.n482 VGND.n421 9.3005
R1681 VGND.n481 VGND.n480 9.3005
R1682 VGND.n479 VGND.n424 9.3005
R1683 VGND.n478 VGND.n477 9.3005
R1684 VGND.n476 VGND.n425 9.3005
R1685 VGND.n475 VGND.n474 9.3005
R1686 VGND.n473 VGND.n428 9.3005
R1687 VGND.n472 VGND.n471 9.3005
R1688 VGND.n470 VGND.n429 9.3005
R1689 VGND.n469 VGND.n468 9.3005
R1690 VGND.n467 VGND.n433 9.3005
R1691 VGND.n466 VGND.n465 9.3005
R1692 VGND.n464 VGND.n434 9.3005
R1693 VGND.n463 VGND.n462 9.3005
R1694 VGND.n461 VGND.n437 9.3005
R1695 VGND.n460 VGND.n459 9.3005
R1696 VGND.n458 VGND.n438 9.3005
R1697 VGND.n457 VGND.n456 9.3005
R1698 VGND.n455 VGND.n441 9.3005
R1699 VGND.n454 VGND.n453 9.3005
R1700 VGND.n452 VGND.n442 9.3005
R1701 VGND.n451 VGND.n450 9.3005
R1702 VGND.n449 VGND.n445 9.3005
R1703 VGND.n448 VGND.n447 9.3005
R1704 VGND.n446 VGND.n5 9.3005
R1705 VGND.n1179 VGND.n2 9.3005
R1706 VGND.n572 VGND.n352 9.3005
R1707 VGND.n577 VGND.n576 9.3005
R1708 VGND.n578 VGND.n312 9.3005
R1709 VGND.n580 VGND.n579 9.3005
R1710 VGND.n581 VGND.n307 9.3005
R1711 VGND.n583 VGND.n582 9.3005
R1712 VGND.n1173 VGND.n1172 9.3005
R1713 VGND.n1171 VGND.n15 9.3005
R1714 VGND.n1170 VGND.n1169 9.3005
R1715 VGND.n1168 VGND.n1153 9.3005
R1716 VGND.n1167 VGND.n1166 9.3005
R1717 VGND.n813 VGND.n812 9.3005
R1718 VGND.n585 VGND.n584 9.3005
R1719 VGND.n807 VGND.n806 9.3005
R1720 VGND.n805 VGND.n587 9.3005
R1721 VGND.n804 VGND.n803 9.3005
R1722 VGND.n589 VGND.n588 9.3005
R1723 VGND.n797 VGND.n796 9.3005
R1724 VGND.n795 VGND.n591 9.3005
R1725 VGND.n794 VGND.n793 9.3005
R1726 VGND.n593 VGND.n592 9.3005
R1727 VGND.n788 VGND.n787 9.3005
R1728 VGND.n786 VGND.n595 9.3005
R1729 VGND.n785 VGND.n784 9.3005
R1730 VGND.n597 VGND.n596 9.3005
R1731 VGND.n775 VGND.n599 9.3005
R1732 VGND.n777 VGND.n776 9.3005
R1733 VGND.n774 VGND.n601 9.3005
R1734 VGND.n773 VGND.n772 9.3005
R1735 VGND.n603 VGND.n602 9.3005
R1736 VGND.n767 VGND.n766 9.3005
R1737 VGND.n765 VGND.n605 9.3005
R1738 VGND.n764 VGND.n763 9.3005
R1739 VGND.n607 VGND.n606 9.3005
R1740 VGND.n757 VGND.n756 9.3005
R1741 VGND.n755 VGND.n609 9.3005
R1742 VGND.n754 VGND.n753 9.3005
R1743 VGND.n611 VGND.n610 9.3005
R1744 VGND.n748 VGND.n747 9.3005
R1745 VGND.n746 VGND.n613 9.3005
R1746 VGND.n745 VGND.n744 9.3005
R1747 VGND.n615 VGND.n614 9.3005
R1748 VGND.n738 VGND.n737 9.3005
R1749 VGND.n736 VGND.n617 9.3005
R1750 VGND.n735 VGND.n734 9.3005
R1751 VGND.n619 VGND.n618 9.3005
R1752 VGND.n728 VGND.n727 9.3005
R1753 VGND.n726 VGND.n621 9.3005
R1754 VGND.n725 VGND.n724 9.3005
R1755 VGND.n623 VGND.n622 9.3005
R1756 VGND.n715 VGND.n624 9.3005
R1757 VGND.n717 VGND.n716 9.3005
R1758 VGND.n714 VGND.n626 9.3005
R1759 VGND.n713 VGND.n712 9.3005
R1760 VGND.n628 VGND.n627 9.3005
R1761 VGND.n706 VGND.n705 9.3005
R1762 VGND.n704 VGND.n630 9.3005
R1763 VGND.n703 VGND.n702 9.3005
R1764 VGND.n632 VGND.n631 9.3005
R1765 VGND.n697 VGND.n696 9.3005
R1766 VGND.n695 VGND.n634 9.3005
R1767 VGND.n694 VGND.n693 9.3005
R1768 VGND.n636 VGND.n635 9.3005
R1769 VGND.n687 VGND.n686 9.3005
R1770 VGND.n685 VGND.n638 9.3005
R1771 VGND.n684 VGND.n683 9.3005
R1772 VGND.n640 VGND.n639 9.3005
R1773 VGND.n677 VGND.n676 9.3005
R1774 VGND.n675 VGND.n642 9.3005
R1775 VGND.n674 VGND.n673 9.3005
R1776 VGND.n644 VGND.n643 9.3005
R1777 VGND.n668 VGND.n667 9.3005
R1778 VGND.n666 VGND.n646 9.3005
R1779 VGND.n665 VGND.n664 9.3005
R1780 VGND.n648 VGND.n647 9.3005
R1781 VGND.n654 VGND.n649 9.3005
R1782 VGND.n656 VGND.n655 9.3005
R1783 VGND.n653 VGND.n652 9.3005
R1784 VGND.n301 VGND.n300 9.3005
R1785 VGND.n1145 VGND.n1143 9.3005
R1786 VGND.n1142 VGND.n22 9.3005
R1787 VGND.n1141 VGND.n1140 9.3005
R1788 VGND.n24 VGND.n23 9.3005
R1789 VGND.n1127 VGND.n1126 9.3005
R1790 VGND.n1125 VGND.n36 9.3005
R1791 VGND.n1124 VGND.n1123 9.3005
R1792 VGND.n38 VGND.n37 9.3005
R1793 VGND.n1111 VGND.n1110 9.3005
R1794 VGND.n1109 VGND.n50 9.3005
R1795 VGND.n1108 VGND.n1107 9.3005
R1796 VGND.n52 VGND.n51 9.3005
R1797 VGND.n1095 VGND.n1094 9.3005
R1798 VGND.n1093 VGND.n64 9.3005
R1799 VGND.n1092 VGND.n1091 9.3005
R1800 VGND.n66 VGND.n65 9.3005
R1801 VGND.n1079 VGND.n1078 9.3005
R1802 VGND.n1077 VGND.n78 9.3005
R1803 VGND.n1076 VGND.n1075 9.3005
R1804 VGND.n80 VGND.n79 9.3005
R1805 VGND.n1063 VGND.n1062 9.3005
R1806 VGND.n1061 VGND.n92 9.3005
R1807 VGND.n1060 VGND.n1059 9.3005
R1808 VGND.n94 VGND.n93 9.3005
R1809 VGND.n1047 VGND.n1046 9.3005
R1810 VGND.n1045 VGND.n105 9.3005
R1811 VGND.n1044 VGND.n1043 9.3005
R1812 VGND.n107 VGND.n106 9.3005
R1813 VGND.n1031 VGND.n1030 9.3005
R1814 VGND.n1029 VGND.n119 9.3005
R1815 VGND.n1028 VGND.n1027 9.3005
R1816 VGND.n121 VGND.n120 9.3005
R1817 VGND.n1015 VGND.n1014 9.3005
R1818 VGND.n1013 VGND.n133 9.3005
R1819 VGND.n1012 VGND.n1011 9.3005
R1820 VGND.n135 VGND.n134 9.3005
R1821 VGND.n999 VGND.n998 9.3005
R1822 VGND.n997 VGND.n147 9.3005
R1823 VGND.n996 VGND.n995 9.3005
R1824 VGND.n149 VGND.n148 9.3005
R1825 VGND.n984 VGND.n983 9.3005
R1826 VGND.n982 VGND.n160 9.3005
R1827 VGND.n981 VGND.n980 9.3005
R1828 VGND.n162 VGND.n161 9.3005
R1829 VGND.n968 VGND.n967 9.3005
R1830 VGND.n966 VGND.n174 9.3005
R1831 VGND.n965 VGND.n964 9.3005
R1832 VGND.n176 VGND.n175 9.3005
R1833 VGND.n952 VGND.n951 9.3005
R1834 VGND.n950 VGND.n188 9.3005
R1835 VGND.n949 VGND.n948 9.3005
R1836 VGND.n190 VGND.n189 9.3005
R1837 VGND.n936 VGND.n935 9.3005
R1838 VGND.n934 VGND.n202 9.3005
R1839 VGND.n933 VGND.n932 9.3005
R1840 VGND.n204 VGND.n203 9.3005
R1841 VGND.n920 VGND.n919 9.3005
R1842 VGND.n918 VGND.n216 9.3005
R1843 VGND.n917 VGND.n916 9.3005
R1844 VGND.n218 VGND.n217 9.3005
R1845 VGND.n904 VGND.n903 9.3005
R1846 VGND.n902 VGND.n229 9.3005
R1847 VGND.n901 VGND.n900 9.3005
R1848 VGND.n231 VGND.n230 9.3005
R1849 VGND.n888 VGND.n887 9.3005
R1850 VGND.n886 VGND.n243 9.3005
R1851 VGND.n885 VGND.n884 9.3005
R1852 VGND.n245 VGND.n244 9.3005
R1853 VGND.n872 VGND.n871 9.3005
R1854 VGND.n870 VGND.n257 9.3005
R1855 VGND.n869 VGND.n868 9.3005
R1856 VGND.n259 VGND.n258 9.3005
R1857 VGND.n856 VGND.n855 9.3005
R1858 VGND.n854 VGND.n271 9.3005
R1859 VGND.n853 VGND.n852 9.3005
R1860 VGND.n273 VGND.n272 9.3005
R1861 VGND.n840 VGND.n839 9.3005
R1862 VGND.n838 VGND.n285 9.3005
R1863 VGND.n837 VGND.n836 9.3005
R1864 VGND.n287 VGND.n286 9.3005
R1865 VGND.n824 VGND.n823 9.3005
R1866 VGND.n822 VGND.n299 9.3005
R1867 VGND.n821 VGND.n820 9.3005
R1868 VGND.n1025 VGND.t29 8.13769
R1869 VGND.n234 VGND.t63 8.13769
R1870 VGND.n41 VGND.t1 6.6582
R1871 VGND.t19 VGND.n89 6.6582
R1872 VGND.n866 VGND.t73 6.6582
R1873 VGND.n1097 VGND.t9 5.17871
R1874 VGND.n1089 VGND.t11 5.17871
R1875 VGND.n1175 VGND.n12 4.90034
R1876 VGND.n574 VGND.n573 4.82369
R1877 VGND.n575 VGND.n574 4.82369
R1878 VGND.n1144 VGND.n12 4.79939
R1879 VGND.n816 VGND.n815 4.6505
R1880 VGND.n294 VGND.n293 4.6505
R1881 VGND.n829 VGND.n828 4.6505
R1882 VGND.n830 VGND.n292 4.6505
R1883 VGND.n832 VGND.n831 4.6505
R1884 VGND.n280 VGND.n279 4.6505
R1885 VGND.n845 VGND.n844 4.6505
R1886 VGND.n846 VGND.n278 4.6505
R1887 VGND.n848 VGND.n847 4.6505
R1888 VGND.n266 VGND.n265 4.6505
R1889 VGND.n861 VGND.n860 4.6505
R1890 VGND.n862 VGND.n264 4.6505
R1891 VGND.n864 VGND.n863 4.6505
R1892 VGND.n252 VGND.n251 4.6505
R1893 VGND.n877 VGND.n876 4.6505
R1894 VGND.n878 VGND.n250 4.6505
R1895 VGND.n880 VGND.n879 4.6505
R1896 VGND.n238 VGND.n237 4.6505
R1897 VGND.n893 VGND.n892 4.6505
R1898 VGND.n894 VGND.n236 4.6505
R1899 VGND.n896 VGND.n895 4.6505
R1900 VGND.n225 VGND.n224 4.6505
R1901 VGND.n909 VGND.n908 4.6505
R1902 VGND.n910 VGND.n223 4.6505
R1903 VGND.n912 VGND.n911 4.6505
R1904 VGND.n211 VGND.n210 4.6505
R1905 VGND.n925 VGND.n924 4.6505
R1906 VGND.n926 VGND.n209 4.6505
R1907 VGND.n928 VGND.n927 4.6505
R1908 VGND.n197 VGND.n196 4.6505
R1909 VGND.n941 VGND.n940 4.6505
R1910 VGND.n942 VGND.n195 4.6505
R1911 VGND.n944 VGND.n943 4.6505
R1912 VGND.n183 VGND.n182 4.6505
R1913 VGND.n957 VGND.n956 4.6505
R1914 VGND.n958 VGND.n181 4.6505
R1915 VGND.n960 VGND.n959 4.6505
R1916 VGND.n169 VGND.n168 4.6505
R1917 VGND.n973 VGND.n972 4.6505
R1918 VGND.n974 VGND.n167 4.6505
R1919 VGND.n976 VGND.n975 4.6505
R1920 VGND.n156 VGND.n155 4.6505
R1921 VGND.n988 VGND.n987 4.6505
R1922 VGND.n989 VGND.n154 4.6505
R1923 VGND.n991 VGND.n990 4.6505
R1924 VGND.n142 VGND.n141 4.6505
R1925 VGND.n1004 VGND.n1003 4.6505
R1926 VGND.n1005 VGND.n140 4.6505
R1927 VGND.n1007 VGND.n1006 4.6505
R1928 VGND.n128 VGND.n127 4.6505
R1929 VGND.n1020 VGND.n1019 4.6505
R1930 VGND.n1021 VGND.n126 4.6505
R1931 VGND.n1023 VGND.n1022 4.6505
R1932 VGND.n114 VGND.n113 4.6505
R1933 VGND.n1036 VGND.n1035 4.6505
R1934 VGND.n1037 VGND.n112 4.6505
R1935 VGND.n1039 VGND.n1038 4.6505
R1936 VGND.n100 VGND.n99 4.6505
R1937 VGND.n1052 VGND.n1051 4.6505
R1938 VGND.n1053 VGND.n98 4.6505
R1939 VGND.n1055 VGND.n1054 4.6505
R1940 VGND.n87 VGND.n86 4.6505
R1941 VGND.n1068 VGND.n1067 4.6505
R1942 VGND.n1069 VGND.n85 4.6505
R1943 VGND.n1071 VGND.n1070 4.6505
R1944 VGND.n73 VGND.n72 4.6505
R1945 VGND.n1084 VGND.n1083 4.6505
R1946 VGND.n1085 VGND.n71 4.6505
R1947 VGND.n1087 VGND.n1086 4.6505
R1948 VGND.n59 VGND.n58 4.6505
R1949 VGND.n1100 VGND.n1099 4.6505
R1950 VGND.n1101 VGND.n57 4.6505
R1951 VGND.n1103 VGND.n1102 4.6505
R1952 VGND.n45 VGND.n44 4.6505
R1953 VGND.n1116 VGND.n1115 4.6505
R1954 VGND.n1117 VGND.n43 4.6505
R1955 VGND.n1119 VGND.n1118 4.6505
R1956 VGND.n32 VGND.n31 4.6505
R1957 VGND.n1132 VGND.n1131 4.6505
R1958 VGND.n1133 VGND.n29 4.6505
R1959 VGND.n1136 VGND.n1135 4.6505
R1960 VGND.n1134 VGND.n30 4.6505
R1961 VGND.n17 VGND.n16 4.6505
R1962 VGND.n1151 VGND.n1150 4.6505
R1963 VGND.n1152 VGND.n13 4.6505
R1964 VGND.n103 VGND.t21 3.69922
R1965 VGND.n874 VGND.t71 3.69922
R1966 VGND.n1143 VGND.n12 2.47089
R1967 VGND.n574 VGND.n352 2.23966
R1968 VGND.n1017 VGND.t31 2.21973
R1969 VGND.t61 VGND.n220 2.21973
R1970 VGND.n165 VGND.t41 0.740244
R1971 VGND.n946 VGND.t51 0.740244
R1972 VGND.n821 VGND.n300 0.476043
R1973 VGND.n1181 VGND.n2 0.387097
R1974 VGND.n1172 VGND.n1152 0.367537
R1975 VGND.n570 VGND.n352 0.318435
R1976 VGND.n352 VGND.n351 0.30425
R1977 VGND VGND.n0 0.297375
R1978 VGND.n814 VGND.n813 0.291261
R1979 VGND.n814 VGND.n583 0.23963
R1980 VGND.n446 VGND.n2 0.196152
R1981 VGND.n448 VGND.n446 0.196152
R1982 VGND.n449 VGND.n448 0.196152
R1983 VGND.n450 VGND.n449 0.196152
R1984 VGND.n450 VGND.n442 0.196152
R1985 VGND.n454 VGND.n442 0.196152
R1986 VGND.n455 VGND.n454 0.196152
R1987 VGND.n456 VGND.n455 0.196152
R1988 VGND.n456 VGND.n438 0.196152
R1989 VGND.n460 VGND.n438 0.196152
R1990 VGND.n461 VGND.n460 0.196152
R1991 VGND.n462 VGND.n461 0.196152
R1992 VGND.n462 VGND.n434 0.196152
R1993 VGND.n466 VGND.n434 0.196152
R1994 VGND.n467 VGND.n466 0.196152
R1995 VGND.n468 VGND.n467 0.196152
R1996 VGND.n468 VGND.n429 0.196152
R1997 VGND.n472 VGND.n429 0.196152
R1998 VGND.n473 VGND.n472 0.196152
R1999 VGND.n474 VGND.n473 0.196152
R2000 VGND.n474 VGND.n425 0.196152
R2001 VGND.n478 VGND.n425 0.196152
R2002 VGND.n479 VGND.n478 0.196152
R2003 VGND.n480 VGND.n479 0.196152
R2004 VGND.n480 VGND.n421 0.196152
R2005 VGND.n484 VGND.n421 0.196152
R2006 VGND.n485 VGND.n484 0.196152
R2007 VGND.n486 VGND.n485 0.196152
R2008 VGND.n486 VGND.n417 0.196152
R2009 VGND.n490 VGND.n417 0.196152
R2010 VGND.n491 VGND.n490 0.196152
R2011 VGND.n492 VGND.n491 0.196152
R2012 VGND.n492 VGND.n412 0.196152
R2013 VGND.n496 VGND.n412 0.196152
R2014 VGND.n497 VGND.n496 0.196152
R2015 VGND.n498 VGND.n497 0.196152
R2016 VGND.n498 VGND.n408 0.196152
R2017 VGND.n502 VGND.n408 0.196152
R2018 VGND.n503 VGND.n502 0.196152
R2019 VGND.n504 VGND.n503 0.196152
R2020 VGND.n504 VGND.n404 0.196152
R2021 VGND.n508 VGND.n404 0.196152
R2022 VGND.n509 VGND.n508 0.196152
R2023 VGND.n510 VGND.n509 0.196152
R2024 VGND.n510 VGND.n400 0.196152
R2025 VGND.n514 VGND.n400 0.196152
R2026 VGND.n515 VGND.n514 0.196152
R2027 VGND.n516 VGND.n515 0.196152
R2028 VGND.n516 VGND.n396 0.196152
R2029 VGND.n520 VGND.n396 0.196152
R2030 VGND.n521 VGND.n520 0.196152
R2031 VGND.n522 VGND.n521 0.196152
R2032 VGND.n522 VGND.n391 0.196152
R2033 VGND.n526 VGND.n391 0.196152
R2034 VGND.n527 VGND.n526 0.196152
R2035 VGND.n528 VGND.n527 0.196152
R2036 VGND.n528 VGND.n387 0.196152
R2037 VGND.n532 VGND.n387 0.196152
R2038 VGND.n533 VGND.n532 0.196152
R2039 VGND.n534 VGND.n533 0.196152
R2040 VGND.n534 VGND.n383 0.196152
R2041 VGND.n538 VGND.n383 0.196152
R2042 VGND.n539 VGND.n538 0.196152
R2043 VGND.n540 VGND.n539 0.196152
R2044 VGND.n540 VGND.n379 0.196152
R2045 VGND.n544 VGND.n379 0.196152
R2046 VGND.n545 VGND.n544 0.196152
R2047 VGND.n546 VGND.n545 0.196152
R2048 VGND.n546 VGND.n375 0.196152
R2049 VGND.n550 VGND.n375 0.196152
R2050 VGND.n551 VGND.n550 0.196152
R2051 VGND.n552 VGND.n551 0.196152
R2052 VGND.n552 VGND.n370 0.196152
R2053 VGND.n556 VGND.n370 0.196152
R2054 VGND.n557 VGND.n556 0.196152
R2055 VGND.n558 VGND.n557 0.196152
R2056 VGND.n558 VGND.n366 0.196152
R2057 VGND.n562 VGND.n366 0.196152
R2058 VGND.n563 VGND.n562 0.196152
R2059 VGND.n564 VGND.n563 0.196152
R2060 VGND.n564 VGND.n362 0.196152
R2061 VGND.n568 VGND.n362 0.196152
R2062 VGND.n569 VGND.n568 0.196152
R2063 VGND.n570 VGND.n569 0.196152
R2064 VGND.n1143 VGND.n1142 0.196152
R2065 VGND.n1142 VGND.n1141 0.196152
R2066 VGND.n1141 VGND.n23 0.196152
R2067 VGND.n1126 VGND.n23 0.196152
R2068 VGND.n1126 VGND.n1125 0.196152
R2069 VGND.n1125 VGND.n1124 0.196152
R2070 VGND.n1124 VGND.n37 0.196152
R2071 VGND.n1110 VGND.n37 0.196152
R2072 VGND.n1110 VGND.n1109 0.196152
R2073 VGND.n1109 VGND.n1108 0.196152
R2074 VGND.n1108 VGND.n51 0.196152
R2075 VGND.n1094 VGND.n51 0.196152
R2076 VGND.n1094 VGND.n1093 0.196152
R2077 VGND.n1093 VGND.n1092 0.196152
R2078 VGND.n1092 VGND.n65 0.196152
R2079 VGND.n1078 VGND.n65 0.196152
R2080 VGND.n1078 VGND.n1077 0.196152
R2081 VGND.n1077 VGND.n1076 0.196152
R2082 VGND.n1076 VGND.n79 0.196152
R2083 VGND.n1062 VGND.n79 0.196152
R2084 VGND.n1062 VGND.n1061 0.196152
R2085 VGND.n1061 VGND.n1060 0.196152
R2086 VGND.n1060 VGND.n93 0.196152
R2087 VGND.n1046 VGND.n93 0.196152
R2088 VGND.n1046 VGND.n1045 0.196152
R2089 VGND.n1045 VGND.n1044 0.196152
R2090 VGND.n1044 VGND.n106 0.196152
R2091 VGND.n1030 VGND.n106 0.196152
R2092 VGND.n1030 VGND.n1029 0.196152
R2093 VGND.n1029 VGND.n1028 0.196152
R2094 VGND.n1028 VGND.n120 0.196152
R2095 VGND.n1014 VGND.n120 0.196152
R2096 VGND.n1014 VGND.n1013 0.196152
R2097 VGND.n1013 VGND.n1012 0.196152
R2098 VGND.n1012 VGND.n134 0.196152
R2099 VGND.n998 VGND.n134 0.196152
R2100 VGND.n998 VGND.n997 0.196152
R2101 VGND.n997 VGND.n996 0.196152
R2102 VGND.n996 VGND.n148 0.196152
R2103 VGND.n983 VGND.n148 0.196152
R2104 VGND.n983 VGND.n982 0.196152
R2105 VGND.n982 VGND.n981 0.196152
R2106 VGND.n981 VGND.n161 0.196152
R2107 VGND.n967 VGND.n161 0.196152
R2108 VGND.n967 VGND.n966 0.196152
R2109 VGND.n966 VGND.n965 0.196152
R2110 VGND.n965 VGND.n175 0.196152
R2111 VGND.n951 VGND.n175 0.196152
R2112 VGND.n951 VGND.n950 0.196152
R2113 VGND.n950 VGND.n949 0.196152
R2114 VGND.n949 VGND.n189 0.196152
R2115 VGND.n935 VGND.n189 0.196152
R2116 VGND.n935 VGND.n934 0.196152
R2117 VGND.n934 VGND.n933 0.196152
R2118 VGND.n933 VGND.n203 0.196152
R2119 VGND.n919 VGND.n203 0.196152
R2120 VGND.n919 VGND.n918 0.196152
R2121 VGND.n918 VGND.n917 0.196152
R2122 VGND.n917 VGND.n217 0.196152
R2123 VGND.n903 VGND.n217 0.196152
R2124 VGND.n903 VGND.n902 0.196152
R2125 VGND.n902 VGND.n901 0.196152
R2126 VGND.n901 VGND.n230 0.196152
R2127 VGND.n887 VGND.n230 0.196152
R2128 VGND.n887 VGND.n886 0.196152
R2129 VGND.n886 VGND.n885 0.196152
R2130 VGND.n885 VGND.n244 0.196152
R2131 VGND.n871 VGND.n244 0.196152
R2132 VGND.n871 VGND.n870 0.196152
R2133 VGND.n870 VGND.n869 0.196152
R2134 VGND.n869 VGND.n258 0.196152
R2135 VGND.n855 VGND.n258 0.196152
R2136 VGND.n855 VGND.n854 0.196152
R2137 VGND.n854 VGND.n853 0.196152
R2138 VGND.n853 VGND.n272 0.196152
R2139 VGND.n839 VGND.n272 0.196152
R2140 VGND.n839 VGND.n838 0.196152
R2141 VGND.n838 VGND.n837 0.196152
R2142 VGND.n837 VGND.n286 0.196152
R2143 VGND.n823 VGND.n286 0.196152
R2144 VGND.n823 VGND.n822 0.196152
R2145 VGND.n822 VGND.n821 0.196152
R2146 VGND.n813 VGND.n584 0.196152
R2147 VGND.n806 VGND.n584 0.196152
R2148 VGND.n806 VGND.n805 0.196152
R2149 VGND.n805 VGND.n804 0.196152
R2150 VGND.n804 VGND.n588 0.196152
R2151 VGND.n796 VGND.n588 0.196152
R2152 VGND.n796 VGND.n795 0.196152
R2153 VGND.n795 VGND.n794 0.196152
R2154 VGND.n794 VGND.n592 0.196152
R2155 VGND.n787 VGND.n592 0.196152
R2156 VGND.n787 VGND.n786 0.196152
R2157 VGND.n786 VGND.n785 0.196152
R2158 VGND.n785 VGND.n596 0.196152
R2159 VGND.n775 VGND.n596 0.196152
R2160 VGND.n776 VGND.n775 0.196152
R2161 VGND.n776 VGND.n774 0.196152
R2162 VGND.n774 VGND.n773 0.196152
R2163 VGND.n773 VGND.n602 0.196152
R2164 VGND.n766 VGND.n602 0.196152
R2165 VGND.n766 VGND.n765 0.196152
R2166 VGND.n765 VGND.n764 0.196152
R2167 VGND.n764 VGND.n606 0.196152
R2168 VGND.n756 VGND.n606 0.196152
R2169 VGND.n756 VGND.n755 0.196152
R2170 VGND.n755 VGND.n754 0.196152
R2171 VGND.n754 VGND.n610 0.196152
R2172 VGND.n747 VGND.n610 0.196152
R2173 VGND.n747 VGND.n746 0.196152
R2174 VGND.n746 VGND.n745 0.196152
R2175 VGND.n745 VGND.n614 0.196152
R2176 VGND.n737 VGND.n614 0.196152
R2177 VGND.n737 VGND.n736 0.196152
R2178 VGND.n736 VGND.n735 0.196152
R2179 VGND.n735 VGND.n618 0.196152
R2180 VGND.n727 VGND.n618 0.196152
R2181 VGND.n727 VGND.n726 0.196152
R2182 VGND.n726 VGND.n725 0.196152
R2183 VGND.n725 VGND.n622 0.196152
R2184 VGND.n715 VGND.n622 0.196152
R2185 VGND.n716 VGND.n715 0.196152
R2186 VGND.n716 VGND.n714 0.196152
R2187 VGND.n714 VGND.n713 0.196152
R2188 VGND.n713 VGND.n627 0.196152
R2189 VGND.n705 VGND.n627 0.196152
R2190 VGND.n705 VGND.n704 0.196152
R2191 VGND.n704 VGND.n703 0.196152
R2192 VGND.n703 VGND.n631 0.196152
R2193 VGND.n696 VGND.n631 0.196152
R2194 VGND.n696 VGND.n695 0.196152
R2195 VGND.n695 VGND.n694 0.196152
R2196 VGND.n694 VGND.n635 0.196152
R2197 VGND.n686 VGND.n635 0.196152
R2198 VGND.n686 VGND.n685 0.196152
R2199 VGND.n685 VGND.n684 0.196152
R2200 VGND.n684 VGND.n639 0.196152
R2201 VGND.n676 VGND.n639 0.196152
R2202 VGND.n676 VGND.n675 0.196152
R2203 VGND.n675 VGND.n674 0.196152
R2204 VGND.n674 VGND.n643 0.196152
R2205 VGND.n667 VGND.n643 0.196152
R2206 VGND.n667 VGND.n666 0.196152
R2207 VGND.n666 VGND.n665 0.196152
R2208 VGND.n665 VGND.n647 0.196152
R2209 VGND.n654 VGND.n647 0.196152
R2210 VGND.n655 VGND.n654 0.196152
R2211 VGND.n655 VGND.n653 0.196152
R2212 VGND.n653 VGND.n300 0.196152
R2213 VGND.n1166 VGND.n1153 0.196152
R2214 VGND.n1170 VGND.n1153 0.196152
R2215 VGND.n1171 VGND.n1170 0.196152
R2216 VGND.n1172 VGND.n1171 0.196152
R2217 VGND.n578 VGND.n577 0.196152
R2218 VGND.n579 VGND.n578 0.196152
R2219 VGND.n579 VGND.n307 0.196152
R2220 VGND.n583 VGND.n307 0.196152
R2221 VGND.n1166 VGND.n1165 0.179886
R2222 VGND.n320 VGND.n318 0.16425
R2223 VGND.n318 VGND.n316 0.163625
R2224 VGND.n330 VGND.n328 0.163625
R2225 VGND.n342 VGND.n340 0.163625
R2226 VGND.n348 VGND.n346 0.163625
R2227 VGND.n350 VGND.n348 0.163625
R2228 VGND.n316 VGND.n314 0.163
R2229 VGND.n324 VGND.n322 0.163
R2230 VGND.n326 VGND.n324 0.163
R2231 VGND.n332 VGND.n330 0.163
R2232 VGND.n334 VGND.n332 0.163
R2233 VGND.n336 VGND.n334 0.163
R2234 VGND.n338 VGND.n336 0.163
R2235 VGND.n340 VGND.n338 0.163
R2236 VGND.n346 VGND.n344 0.163
R2237 VGND.n322 VGND.n320 0.162375
R2238 VGND.n328 VGND.n326 0.162375
R2239 VGND.n351 VGND.n350 0.162375
R2240 VGND.n314 VGND.n0 0.16175
R2241 VGND.n344 VGND.n342 0.16175
R2242 VGND.n577 VGND.n352 0.149957
R2243 VGND.n1165 VGND.n1 0.127261
R2244 VGND VGND.n1181 0.107894
R2245 VGND.n1152 VGND.n1151 0.105151
R2246 VGND.n1151 VGND.n16 0.105151
R2247 VGND.n1134 VGND.n16 0.105151
R2248 VGND.n1135 VGND.n1134 0.105151
R2249 VGND.n1135 VGND.n1133 0.105151
R2250 VGND.n1133 VGND.n1132 0.105151
R2251 VGND.n1132 VGND.n31 0.105151
R2252 VGND.n1118 VGND.n31 0.105151
R2253 VGND.n1118 VGND.n1117 0.105151
R2254 VGND.n1117 VGND.n1116 0.105151
R2255 VGND.n1116 VGND.n44 0.105151
R2256 VGND.n1102 VGND.n44 0.105151
R2257 VGND.n1102 VGND.n1101 0.105151
R2258 VGND.n1101 VGND.n1100 0.105151
R2259 VGND.n1100 VGND.n58 0.105151
R2260 VGND.n1086 VGND.n58 0.105151
R2261 VGND.n1086 VGND.n1085 0.105151
R2262 VGND.n1085 VGND.n1084 0.105151
R2263 VGND.n1084 VGND.n72 0.105151
R2264 VGND.n1070 VGND.n72 0.105151
R2265 VGND.n1070 VGND.n1069 0.105151
R2266 VGND.n1069 VGND.n1068 0.105151
R2267 VGND.n1068 VGND.n86 0.105151
R2268 VGND.n1054 VGND.n86 0.105151
R2269 VGND.n1054 VGND.n1053 0.105151
R2270 VGND.n1053 VGND.n1052 0.105151
R2271 VGND.n1052 VGND.n99 0.105151
R2272 VGND.n1038 VGND.n99 0.105151
R2273 VGND.n1038 VGND.n1037 0.105151
R2274 VGND.n1037 VGND.n1036 0.105151
R2275 VGND.n1036 VGND.n113 0.105151
R2276 VGND.n1022 VGND.n113 0.105151
R2277 VGND.n1022 VGND.n1021 0.105151
R2278 VGND.n1021 VGND.n1020 0.105151
R2279 VGND.n1020 VGND.n127 0.105151
R2280 VGND.n1006 VGND.n127 0.105151
R2281 VGND.n1006 VGND.n1005 0.105151
R2282 VGND.n1005 VGND.n1004 0.105151
R2283 VGND.n1004 VGND.n141 0.105151
R2284 VGND.n990 VGND.n141 0.105151
R2285 VGND.n990 VGND.n989 0.105151
R2286 VGND.n989 VGND.n988 0.105151
R2287 VGND.n988 VGND.n155 0.105151
R2288 VGND.n975 VGND.n155 0.105151
R2289 VGND.n975 VGND.n974 0.105151
R2290 VGND.n974 VGND.n973 0.105151
R2291 VGND.n973 VGND.n168 0.105151
R2292 VGND.n959 VGND.n168 0.105151
R2293 VGND.n959 VGND.n958 0.105151
R2294 VGND.n958 VGND.n957 0.105151
R2295 VGND.n957 VGND.n182 0.105151
R2296 VGND.n943 VGND.n182 0.105151
R2297 VGND.n943 VGND.n942 0.105151
R2298 VGND.n942 VGND.n941 0.105151
R2299 VGND.n941 VGND.n196 0.105151
R2300 VGND.n927 VGND.n196 0.105151
R2301 VGND.n927 VGND.n926 0.105151
R2302 VGND.n926 VGND.n925 0.105151
R2303 VGND.n925 VGND.n210 0.105151
R2304 VGND.n911 VGND.n210 0.105151
R2305 VGND.n911 VGND.n910 0.105151
R2306 VGND.n910 VGND.n909 0.105151
R2307 VGND.n909 VGND.n224 0.105151
R2308 VGND.n895 VGND.n224 0.105151
R2309 VGND.n895 VGND.n894 0.105151
R2310 VGND.n894 VGND.n893 0.105151
R2311 VGND.n893 VGND.n237 0.105151
R2312 VGND.n879 VGND.n237 0.105151
R2313 VGND.n879 VGND.n878 0.105151
R2314 VGND.n878 VGND.n877 0.105151
R2315 VGND.n877 VGND.n251 0.105151
R2316 VGND.n863 VGND.n251 0.105151
R2317 VGND.n863 VGND.n862 0.105151
R2318 VGND.n862 VGND.n861 0.105151
R2319 VGND.n861 VGND.n265 0.105151
R2320 VGND.n847 VGND.n265 0.105151
R2321 VGND.n847 VGND.n846 0.105151
R2322 VGND.n846 VGND.n845 0.105151
R2323 VGND.n845 VGND.n279 0.105151
R2324 VGND.n831 VGND.n279 0.105151
R2325 VGND.n831 VGND.n830 0.105151
R2326 VGND.n830 VGND.n829 0.105151
R2327 VGND.n829 VGND.n293 0.105151
R2328 VGND.n815 VGND.n293 0.105151
R2329 VGND.n815 VGND.n814 0.0993372
R2330 VGND VGND.n1 0.0198662
C3 HIN VGND 3.09291f
C4 HEN VGND 13.18732f
C5 a_584_462# VGND 6.58081f **FLOATING
C6 a_5726_764# VGND 3.84908f **FLOATING
C7 a_5726_3296# VGND 3.85093f **FLOATING
C8 HEN.t38 VGND 0.00438f **FLOATING
C9 HEN.t22 VGND 0.00438f **FLOATING
C10 HEN.n0 VGND 0.01037f **FLOATING
C11 HEN.t19 VGND 0.00438f **FLOATING
C12 HEN.t32 VGND 0.00438f **FLOATING
C13 HEN.n1 VGND 0.01032f **FLOATING
C14 HEN.n2 VGND 0.09496f **FLOATING
C15 HEN.t35 VGND 0.00438f **FLOATING
C16 HEN.t3 VGND 0.00438f **FLOATING
C17 HEN.n3 VGND 0.01032f **FLOATING
C18 HEN.n4 VGND 0.05195f **FLOATING
C19 HEN.t40 VGND 0.00438f **FLOATING
C20 HEN.t25 VGND 0.00438f **FLOATING
C21 HEN.n5 VGND 0.01032f **FLOATING
C22 HEN.n6 VGND 0.05208f **FLOATING
C23 HEN.t10 VGND 0.00438f **FLOATING
C24 HEN.t16 VGND 0.00438f **FLOATING
C25 HEN.n7 VGND 0.01032f **FLOATING
C26 HEN.n8 VGND 0.05208f **FLOATING
C27 HEN.t29 VGND 0.00438f **FLOATING
C28 HEN.t4 VGND 0.00438f **FLOATING
C29 HEN.n9 VGND 0.01032f **FLOATING
C30 HEN.n10 VGND 0.05195f **FLOATING
C31 HEN.t24 VGND 0.00438f **FLOATING
C32 HEN.t41 VGND 0.00438f **FLOATING
C33 HEN.n11 VGND 0.01032f **FLOATING
C34 HEN.n12 VGND 0.05208f **FLOATING
C35 HEN.t15 VGND 0.00438f **FLOATING
C36 HEN.t5 VGND 0.00438f **FLOATING
C37 HEN.n13 VGND 0.01032f **FLOATING
C38 HEN.n14 VGND 0.05208f **FLOATING
C39 HEN.t27 VGND 0.00438f **FLOATING
C40 HEN.t8 VGND 0.00438f **FLOATING
C41 HEN.n15 VGND 0.01032f **FLOATING
C42 HEN.n16 VGND 0.05195f **FLOATING
C43 HEN.t34 VGND 0.00438f **FLOATING
C44 HEN.t12 VGND 0.00438f **FLOATING
C45 HEN.n17 VGND 0.01032f **FLOATING
C46 HEN.n18 VGND 0.05208f **FLOATING
C47 HEN.t36 VGND 0.00438f **FLOATING
C48 HEN.t20 VGND 0.00438f **FLOATING
C49 HEN.n19 VGND 0.01032f **FLOATING
C50 HEN.n20 VGND 0.05208f **FLOATING
C51 HEN.t26 VGND 0.00438f **FLOATING
C52 HEN.t17 VGND 0.00438f **FLOATING
C53 HEN.n21 VGND 0.01032f **FLOATING
C54 HEN.n22 VGND 0.05195f **FLOATING
C55 HEN.t23 VGND 0.00438f **FLOATING
C56 HEN.t30 VGND 0.00438f **FLOATING
C57 HEN.n23 VGND 0.01032f **FLOATING
C58 HEN.n24 VGND 0.05208f **FLOATING
C59 HEN.t9 VGND 0.00438f **FLOATING
C60 HEN.t37 VGND 0.00438f **FLOATING
C61 HEN.n25 VGND 0.01032f **FLOATING
C62 HEN.n26 VGND 0.05208f **FLOATING
C63 HEN.t6 VGND 0.00438f **FLOATING
C64 HEN.t21 VGND 0.00438f **FLOATING
C65 HEN.n27 VGND 0.01032f **FLOATING
C66 HEN.n28 VGND 0.05199f **FLOATING
C67 HEN.t33 VGND 0.00438f **FLOATING
C68 HEN.t2 VGND 0.00438f **FLOATING
C69 HEN.n29 VGND 0.01032f **FLOATING
C70 HEN.n30 VGND 0.05203f **FLOATING
C71 HEN.t28 VGND 0.00438f **FLOATING
C72 HEN.t11 VGND 0.00438f **FLOATING
C73 HEN.n31 VGND 0.01032f **FLOATING
C74 HEN.n32 VGND 0.05203f **FLOATING
C75 HEN.t18 VGND 0.00438f **FLOATING
C76 HEN.t14 VGND 0.00438f **FLOATING
C77 HEN.n33 VGND 0.01032f **FLOATING
C78 HEN.n34 VGND 0.05203f **FLOATING
C79 HEN.t31 VGND 0.00438f **FLOATING
C80 HEN.t39 VGND 0.00438f **FLOATING
C81 HEN.n35 VGND 0.01032f **FLOATING
C82 HEN.n36 VGND 0.05199f **FLOATING
C83 HEN.t1 VGND 0.5635f **FLOATING
C84 HEN.t0 VGND 0.35724f **FLOATING
C85 HEN.n37 VGND 3.52443f **FLOATING
C86 HEN.n38 VGND 0.08681f **FLOATING
C87 HEN.t7 VGND 0.00438f **FLOATING
C88 HEN.t13 VGND 0.00438f **FLOATING
C89 HEN.n39 VGND 0.00924f **FLOATING
C90 HEN.n40 VGND 0.04274f **FLOATING
C91 HIN.t1 VGND 0.5418f **FLOATING
C92 HIN.t0 VGND 0.5418f **FLOATING
C93 HIN.n0 VGND 2.78028f **FLOATING
