* SPICE3 file created from ELAD1_CLAMP.ext - technology: sky130A

X0 VGND CLR NODE VGND sky130_fd_pr__nfet_01v8 ad=0.126 pd=1.44 as=0.126 ps=1.44 w=0.42 l=1
C0 NODE CLR 0.05929f
R0 VGND.n28 VGND.n19 1066.12
R1 VGND.n56 VGND.n2 1066.12
R2 VGND.n53 VGND.n6 1066.12
R3 VGND.n24 VGND.n21 1066.12
R4 VGND.n55 VGND.n5 822.61
R5 VGND.n27 VGND.n20 822.61
R6 VGND.n13 VGND.n5 688.697
R7 VGND.n46 VGND.n13 688.697
R8 VGND.n46 VGND.n12 688.697
R9 VGND.n38 VGND.n12 688.697
R10 VGND.n38 VGND.n20 688.697
R11 VGND.n20 VGND.n19 585
R12 VGND.n19 VGND.n18 585
R13 VGND.n39 VGND.n38 585
R14 VGND.n40 VGND.n39 585
R15 VGND.n14 VGND.n12 585
R16 VGND.n16 VGND.n14 585
R17 VGND.n46 VGND.n45 585
R18 VGND.n45 VGND.n44 585
R19 VGND.n15 VGND.n13 585
R20 VGND.n15 VGND.n1 585
R21 VGND.n5 VGND.n2 585
R22 VGND.n58 VGND.n2 585
R23 VGND.n56 VGND.n55 585
R24 VGND.n57 VGND.n56 585
R25 VGND.n4 VGND.n3 585
R26 VGND.n53 VGND.n52 585
R27 VGND.n6 VGND.n5 585
R28 VGND.n51 VGND.n6 585
R29 VGND.n13 VGND.n11 585
R30 VGND.n11 VGND.n7 585
R31 VGND.n47 VGND.n46 585
R32 VGND.n48 VGND.n47 585
R33 VGND.n12 VGND.n10 585
R34 VGND.n10 VGND.n9 585
R35 VGND.n38 VGND.n37 585
R36 VGND.n37 VGND.n36 585
R37 VGND.n21 VGND.n20 585
R38 VGND.n22 VGND.n21 585
R39 VGND.n32 VGND.n24 585
R40 VGND.n31 VGND.n25 585
R41 VGND.n28 VGND.n27 585
R42 VGND.n30 VGND.n28 585
R43 VGND.n28 VGND.n25 417.176
R44 VGND.n15 VGND.n2 417.176
R45 VGND.n45 VGND.n15 417.176
R46 VGND.n45 VGND.n14 417.176
R47 VGND.n39 VGND.n14 417.176
R48 VGND.n39 VGND.n19 417.176
R49 VGND.n56 VGND.n4 417.176
R50 VGND.n11 VGND.n6 417.176
R51 VGND.n47 VGND.n11 417.176
R52 VGND.n47 VGND.n10 417.176
R53 VGND.n37 VGND.n10 417.176
R54 VGND.n37 VGND.n21 417.176
R55 VGND.n55 VGND.n54 215.619
R56 VGND.n27 VGND.n26 215.619
R57 VGND.n54 VGND.n4 153.763
R58 VGND.n26 VGND.n25 153.763
R59 VGND.n26 VGND.n24 153.763
R60 VGND.n54 VGND.n53 153.763
R61 VGND.n58 VGND.n57 69.2711
R62 VGND.n52 VGND.n51 69.2711
R63 VGND.n30 VGND.n18 69.2711
R64 VGND.n32 VGND.n22 69.2711
R65 VGND.n58 VGND.n1 27.1064
R66 VGND.n44 VGND.n1 27.1064
R67 VGND.n44 VGND.n16 27.1064
R68 VGND.n40 VGND.n16 27.1064
R69 VGND.n40 VGND.n18 27.1064
R70 VGND.n57 VGND.n3 27.1064
R71 VGND.n52 VGND.n3 27.1064
R72 VGND.n48 VGND.n7 27.1064
R73 VGND.n48 VGND.n9 27.1064
R74 VGND.n36 VGND.n9 27.1064
R75 VGND.n36 VGND.n22 27.1064
R76 VGND.n31 VGND.n30 27.1064
R77 VGND.n32 VGND.n31 27.1064
R78 VGND.n41 VGND.n40 9.30266
R79 VGND.n42 VGND.n16 9.3005
R80 VGND.n44 VGND.n43 9.3005
R81 VGND.n1 VGND.n0 9.3005
R82 VGND.n59 VGND.n58 9.3005
R83 VGND.n18 VGND.n17 9.3005
R84 VGND.n49 VGND.n48 9.3005
R85 VGND.n9 VGND.n8 9.3005
R86 VGND.n36 VGND.n35 9.3005
R87 VGND.n34 VGND.n22 9.3005
R88 VGND.n33 VGND.n32 9.3005
R89 VGND.n31 VGND.n23 9.3005
R90 VGND.n30 VGND.n29 9.3005
R91 VGND.n51 VGND.n50 5.60839
R92 VGND.n50 VGND.n7 5.49286
R93 VGND.n50 VGND.n49 2.12054
R94 VGND.n34 VGND.n33 0.448124
R95 VGND.n29 VGND.n17 0.412809
R96 VGND VGND.n59 0.296796
R97 VGND.n49 VGND.n8 0.196152
R98 VGND.n35 VGND.n8 0.196152
R99 VGND.n35 VGND.n34 0.196152
R100 VGND.n29 VGND.n23 0.176971
R101 VGND.n33 VGND.n23 0.176971
R102 VGND.n59 VGND.n0 0.167167
R103 VGND.n43 VGND.n0 0.167167
R104 VGND.n43 VGND.n42 0.167167
R105 VGND.n42 VGND.n41 0.150963
R106 VGND.n41 VGND.n17 0.0491111
C1 VGND.n0 VGND 0.0011f **FLOATING
C2 VGND.n1 VGND 0 **FLOATING
C3 VGND.n2 VGND 0.00132f **FLOATING
C4 VGND.n3 VGND 0 **FLOATING
C5 VGND.n4 VGND 0 **FLOATING
C6 VGND.n5 VGND 0.01032f **FLOATING
C7 VGND.n6 VGND 0.00132f **FLOATING
C8 VGND.n7 VGND 0 **FLOATING
C9 VGND.n8 VGND 0 **FLOATING
C10 VGND.n9 VGND 0 **FLOATING
C11 VGND.n10 VGND 0 **FLOATING
C12 VGND.n11 VGND 0 **FLOATING
C13 VGND.n12 VGND 0.00941f **FLOATING
C14 VGND.n13 VGND 0.00941f **FLOATING
C15 VGND.n14 VGND 0 **FLOATING
C16 VGND.n15 VGND 0 **FLOATING
C17 VGND.n16 VGND 0 **FLOATING
C18 VGND.n17 VGND 0.00169f **FLOATING
C19 VGND.n18 VGND 0.00132f **FLOATING
C20 VGND.n19 VGND 0.00132f **FLOATING
C21 VGND.n20 VGND 0.01032f **FLOATING
C22 VGND.n21 VGND 0.00132f **FLOATING
C23 VGND.n22 VGND 0.00132f **FLOATING
C24 VGND.n23 VGND 0.00104f **FLOATING
C25 VGND.n24 VGND 0.00131f **FLOATING
C26 VGND.n25 VGND 0 **FLOATING
C27 VGND.n27 VGND 0.01124f **FLOATING
C28 VGND.n28 VGND 0.00131f **FLOATING
C29 VGND.n29 VGND 0.00197f **FLOATING
C30 VGND.n30 VGND 0.00131f **FLOATING
C31 VGND.n31 VGND 0 **FLOATING
C32 VGND.n32 VGND 0.00131f **FLOATING
C33 VGND.n33 VGND 0.00193f **FLOATING
C34 VGND.n34 VGND 0.00185f **FLOATING
C35 VGND.n35 VGND 0 **FLOATING
C36 VGND.n36 VGND 0 **FLOATING
C37 VGND.n37 VGND 0 **FLOATING
C38 VGND.n38 VGND 0.00941f **FLOATING
C39 VGND.n39 VGND 0 **FLOATING
C40 VGND.n40 VGND 0 **FLOATING
C41 VGND.n41 VGND 0.00616f **FLOATING
C42 VGND.n42 VGND 0.00105f **FLOATING
C43 VGND.n43 VGND 0.0011f **FLOATING
C44 VGND.n44 VGND 0 **FLOATING
C45 VGND.n45 VGND 0 **FLOATING
C46 VGND.n46 VGND 0.00941f **FLOATING
C47 VGND.n47 VGND 0 **FLOATING
C48 VGND.n48 VGND 0 **FLOATING
C49 VGND.n49 VGND 0.00341f **FLOATING
C50 VGND.n50 VGND 0 **FLOATING
C51 VGND.n51 VGND 0.00136f **FLOATING
C52 VGND.n52 VGND 0.00131f **FLOATING
C53 VGND.n53 VGND 0.00131f **FLOATING
C54 VGND.n55 VGND 0.01124f **FLOATING
C55 VGND.n56 VGND 0.00131f **FLOATING
C56 VGND.n57 VGND 0.00131f **FLOATING
C57 VGND.n58 VGND 0.00132f **FLOATING
C58 VGND.n59 VGND 0.00153f **FLOATING
C59 NODE VGND 0.18938f
C60 CLR VGND 0.7248f
