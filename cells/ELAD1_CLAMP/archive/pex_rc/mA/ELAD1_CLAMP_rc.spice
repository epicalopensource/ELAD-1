* SPICE3 file created from ELAD1_CLAMP_flat.ext - technology: sky130A

X0 VGND.t1 CLR.t0 NODE.t0 VGND.t0 sky130_fd_pr__nfet_01v8 ad=0.126 pd=1.44 as=0.126 ps=1.44 w=0.42 l=1
C0 NODE CLR 0.05929f
R0 NODE NODE.t0 237.542
R1 CLR CLR.t0 71.444
R2 VGND.n26 VGND.n16 1066.12
R3 VGND.n56 VGND.n2 1066.12
R4 VGND.n53 VGND.n6 1066.12
R5 VGND.n22 VGND.n19 1066.12
R6 VGND.n55 VGND.n5 822.61
R7 VGND.n25 VGND.n17 822.61
R8 VGND.n45 VGND.n5 688.697
R9 VGND.n46 VGND.n45 688.697
R10 VGND.n36 VGND.n18 688.697
R11 VGND.n36 VGND.n17 688.697
R12 VGND.n17 VGND.n16 585
R13 VGND.n16 VGND.n15 585
R14 VGND.n37 VGND.n36 585
R15 VGND.n38 VGND.n37 585
R16 VGND.n18 VGND.n12 585
R17 VGND.n13 VGND.n12 585
R18 VGND.n46 VGND.n43 585
R19 VGND.n43 VGND.n42 585
R20 VGND.n45 VGND.n44 585
R21 VGND.n44 VGND.n1 585
R22 VGND.n5 VGND.n2 585
R23 VGND.n58 VGND.n2 585
R24 VGND.n56 VGND.n55 585
R25 VGND.n57 VGND.n56 585
R26 VGND.n4 VGND.n3 585
R27 VGND.n53 VGND.n52 585
R28 VGND.n6 VGND.n5 585
R29 VGND.n51 VGND.n6 585
R30 VGND.n45 VGND.n11 585
R31 VGND.n11 VGND.n7 585
R32 VGND.n47 VGND.n46 585
R33 VGND.n48 VGND.n47 585
R34 VGND.n18 VGND.n10 585
R35 VGND.n10 VGND.n9 585
R36 VGND.n36 VGND.n35 585
R37 VGND.n35 VGND.n34 585
R38 VGND.n19 VGND.n17 585
R39 VGND.n20 VGND.n19 585
R40 VGND.n30 VGND.n22 585
R41 VGND.n29 VGND.n23 585
R42 VGND.n26 VGND.n25 585
R43 VGND.n28 VGND.n26 585
R44 VGND.n26 VGND.n23 417.176
R45 VGND.n44 VGND.n2 417.176
R46 VGND.n44 VGND.n43 417.176
R47 VGND.n43 VGND.n12 417.176
R48 VGND.n37 VGND.n12 417.176
R49 VGND.n37 VGND.n16 417.176
R50 VGND.n56 VGND.n4 417.176
R51 VGND.n11 VGND.n6 417.176
R52 VGND.n47 VGND.n11 417.176
R53 VGND.n47 VGND.n10 417.176
R54 VGND.n35 VGND.n10 417.176
R55 VGND.n35 VGND.n19 417.176
R56 VGND.n46 VGND.t0 344.349
R57 VGND.n18 VGND.t0 344.349
R58 VGND.n39 VGND.t1 237.486
R59 VGND.n55 VGND.n54 215.619
R60 VGND.n25 VGND.n24 215.619
R61 VGND.n54 VGND.n4 153.763
R62 VGND.n24 VGND.n23 153.763
R63 VGND.n24 VGND.n22 153.763
R64 VGND.n54 VGND.n53 153.763
R65 VGND.n58 VGND.n57 69.2711
R66 VGND.n52 VGND.n51 69.2711
R67 VGND.n28 VGND.n15 69.2711
R68 VGND.n30 VGND.n20 69.2711
R69 VGND.n58 VGND.n1 27.1064
R70 VGND.n42 VGND.n1 27.1064
R71 VGND.n42 VGND.n13 27.1064
R72 VGND.n38 VGND.n13 27.1064
R73 VGND.n38 VGND.n15 27.1064
R74 VGND.n57 VGND.n3 27.1064
R75 VGND.n52 VGND.n3 27.1064
R76 VGND.n48 VGND.n7 27.1064
R77 VGND.n48 VGND.n9 27.1064
R78 VGND.n34 VGND.n9 27.1064
R79 VGND.n34 VGND.n20 27.1064
R80 VGND.n29 VGND.n28 27.1064
R81 VGND.n30 VGND.n29 27.1064
R82 VGND.n39 VGND.n38 9.30266
R83 VGND.n40 VGND.n13 9.3005
R84 VGND.n42 VGND.n41 9.3005
R85 VGND.n1 VGND.n0 9.3005
R86 VGND.n59 VGND.n58 9.3005
R87 VGND.n15 VGND.n14 9.3005
R88 VGND.n49 VGND.n48 9.3005
R89 VGND.n9 VGND.n8 9.3005
R90 VGND.n34 VGND.n33 9.3005
R91 VGND.n32 VGND.n20 9.3005
R92 VGND.n31 VGND.n30 9.3005
R93 VGND.n29 VGND.n21 9.3005
R94 VGND.n28 VGND.n27 9.3005
R95 VGND.n51 VGND.n50 5.60839
R96 VGND.n50 VGND.n7 5.49286
R97 VGND.n50 VGND.n49 2.12054
R98 VGND.n32 VGND.n31 0.448124
R99 VGND.n27 VGND.n14 0.412809
R100 VGND VGND.n59 0.296796
R101 VGND.n49 VGND.n8 0.196152
R102 VGND.n33 VGND.n8 0.196152
R103 VGND.n33 VGND.n32 0.196152
R104 VGND.n27 VGND.n21 0.176971
R105 VGND.n31 VGND.n21 0.176971
R106 VGND.n59 VGND.n0 0.167167
R107 VGND.n41 VGND.n0 0.167167
R108 VGND.n41 VGND.n40 0.167167
R109 VGND.n40 VGND.n39 0.150963
R110 VGND.n39 VGND.n14 0.0491111
C1 NODE VGND 0.15808f
C2 CLR VGND 0.60482f
C3 CLR.t0 VGND 0.03377f **FLOATING
C4 NODE.t0 VGND 0.01371f **FLOATING
