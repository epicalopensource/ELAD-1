* SPICE3 file created from ELAD1_MIRROR_CC_flat.ext - technology: sky130A

X0 REF.t15 REF.t14 VGND.t40 VGND.t39 sky130_fd_pr__nfet_01v8 ad=0.25 pd=1.5 as=0.25 ps=1.5 w=1 l=1
X1 VGND.t21 VGND.t19 VGND.t20 VGND.t5 sky130_fd_pr__nfet_01v8 ad=0.25 pd=1.5 as=0 ps=0 w=1 l=1
X2 REF.t13 REF.t12 VGND.t36 VGND.t35 sky130_fd_pr__nfet_01v8 ad=0.25 pd=1.5 as=0.25 ps=1.5 w=1 l=1
X3 VGND.t42 REF.t0 REF.t1 VGND.t41 sky130_fd_pr__nfet_01v8 ad=0.25 pd=1.5 as=0.25 ps=1.5 w=1 l=1
X4 OUT.t5 REF.t19 VGND.t34 VGND.t28 sky130_fd_pr__nfet_01v8 ad=0.25 pd=1.5 as=0.25 ps=1.5 w=1 l=1
X5 VGND.t38 REF.t6 REF.t7 VGND.t37 sky130_fd_pr__nfet_01v8 ad=0.25 pd=1.5 as=0.25 ps=1.5 w=1 l=1
X6 VGND.t11 VGND.t8 VGND.t10 VGND.t9 sky130_fd_pr__nfet_01v8 ad=0.25 pd=1.5 as=0 ps=0 w=1 l=1
X7 OUT.t7 REF.t21 VGND.t33 VGND.t32 sky130_fd_pr__nfet_01v8 ad=0.25 pd=1.5 as=0.25 ps=1.5 w=1 l=1
X8 VGND.t15 VGND.t12 VGND.t14 VGND.t13 sky130_fd_pr__nfet_01v8 ad=0.25 pd=1.5 as=0 ps=0 w=1 l=1
X9 VGND.t45 REF.t18 OUT.t3 VGND.t30 sky130_fd_pr__nfet_01v8 ad=0.25 pd=1.5 as=0.25 ps=1.5 w=1 l=1
X10 VGND.t44 REF.t20 OUT.t2 VGND.t43 sky130_fd_pr__nfet_01v8 ad=0.25 pd=1.5 as=0.25 ps=1.5 w=1 l=1
X11 REF.t3 REF.t2 VGND.t49 VGND.t39 sky130_fd_pr__nfet_01v8 ad=0.25 pd=1.5 as=0.25 ps=1.5 w=1 l=1
X12 REF.t5 REF.t4 VGND.t47 VGND.t35 sky130_fd_pr__nfet_01v8 ad=0.25 pd=1.5 as=0.25 ps=1.5 w=1 l=1
X13 VGND.t50 REF.t10 REF.t11 VGND.t41 sky130_fd_pr__nfet_01v8 ad=0.25 pd=1.5 as=0.25 ps=1.5 w=1 l=1
X14 VGND.t48 REF.t8 REF.t9 VGND.t37 sky130_fd_pr__nfet_01v8 ad=0.25 pd=1.5 as=0.25 ps=1.5 w=1 l=1
X15 VGND.t24 VGND.t22 VGND.t23 VGND.t9 sky130_fd_pr__nfet_01v8 ad=0.25 pd=1.5 as=0 ps=0 w=1 l=1
X16 VGND.t3 VGND.t0 VGND.t2 VGND.t1 sky130_fd_pr__nfet_01v8 ad=0.5 pd=3 as=0 ps=0 w=1 l=1
X17 OUT.t1 REF.t17 VGND.t46 VGND.t32 sky130_fd_pr__nfet_01v8 ad=0.25 pd=1.5 as=0.25 ps=1.5 w=1 l=1
X18 VGND.t27 VGND.t25 VGND.t26 VGND.t13 sky130_fd_pr__nfet_01v8 ad=0.25 pd=1.5 as=0 ps=0 w=1 l=1
X19 VGND.t7 VGND.t4 VGND.t6 VGND.t5 sky130_fd_pr__nfet_01v8 ad=0.25 pd=1.5 as=0 ps=0 w=1 l=1
X20 VGND.t51 REF.t16 OUT.t0 VGND.t43 sky130_fd_pr__nfet_01v8 ad=0.25 pd=1.5 as=0.25 ps=1.5 w=1 l=1
X21 OUT.t4 REF.t23 VGND.t29 VGND.t28 sky130_fd_pr__nfet_01v8 ad=0.25 pd=1.5 as=0.25 ps=1.5 w=1 l=1
X22 VGND.t18 VGND.t16 VGND.t17 VGND.t1 sky130_fd_pr__nfet_01v8 ad=0.5 pd=3 as=0 ps=0 w=1 l=1
X23 VGND.t31 REF.t22 OUT.t6 VGND.t30 sky130_fd_pr__nfet_01v8 ad=0.25 pd=1.5 as=0.25 ps=1.5 w=1 l=1
C0 REF OUT 1.63826f
R0 OUT.n5 OUT.n3 100.008
R1 OUT.n2 OUT.n0 100.008
R2 OUT.n5 OUT.n4 99.9312
R3 OUT.n2 OUT.n1 99.9312
R4 OUT.n3 OUT.t7 30.0005
R5 OUT.n3 OUT.t2 30.0005
R6 OUT.n4 OUT.t1 30.0005
R7 OUT.n4 OUT.t0 30.0005
R8 OUT.n0 OUT.t4 30.0005
R9 OUT.n0 OUT.t6 30.0005
R10 OUT.n1 OUT.t5 30.0005
R11 OUT.n1 OUT.t3 30.0005
R12 OUT.n6 OUT.n2 2.96213
R13 OUT.n6 OUT.n5 1.75545
R14 OUT.n7 OUT.n6 0.85114
R15 OUT OUT.t6 0.0005
R16 REF.n75 REF.n74 184.74
R17 REF.n80 REF.n79 184.74
R18 REF.n85 REF.n84 184.74
R19 REF.n90 REF.n89 184.74
R20 REF.n95 REF.n94 184.74
R21 REF.n100 REF.n99 184.74
R22 REF.n105 REF.n104 184.74
R23 REF.n110 REF.n109 184.74
R24 REF.n71 REF.n28 184.74
R25 REF.n66 REF.n30 184.74
R26 REF.n61 REF.n32 184.74
R27 REF.n48 REF.n34 184.74
R28 REF.n43 REF.n36 184.74
R29 REF.n126 REF.n6 184.74
R30 REF.n121 REF.n8 184.74
R31 REF.n115 REF.n114 184.74
R32 REF.n55 REF.n53 100.234
R33 REF.n3 REF.n2 100.234
R34 REF.n55 REF.n52 99.7053
R35 REF.n3 REF.n1 99.7053
R36 REF.n76 REF.n75 77.1778
R37 REF.n81 REF.n80 77.1778
R38 REF.n86 REF.n85 77.1778
R39 REF.n91 REF.n90 77.1778
R40 REF.n96 REF.n95 77.1778
R41 REF.n101 REF.n100 77.1778
R42 REF.n106 REF.n105 77.1778
R43 REF.n111 REF.n110 77.1778
R44 REF.n69 REF.n28 77.1778
R45 REF.n64 REF.n30 77.1778
R46 REF.n59 REF.n32 77.1778
R47 REF.n46 REF.n34 77.1778
R48 REF.n41 REF.n36 77.1778
R49 REF.n124 REF.n6 77.1778
R50 REF.n119 REF.n8 77.1778
R51 REF.n116 REF.n115 77.1778
R52 REF.n52 REF.t15 30.0005
R53 REF.n52 REF.t1 30.0005
R54 REF.n53 REF.t3 30.0005
R55 REF.n53 REF.t11 30.0005
R56 REF.n1 REF.t13 30.0005
R57 REF.n1 REF.t7 30.0005
R58 REF.n2 REF.t5 30.0005
R59 REF.n2 REF.t9 30.0005
R60 REF.n74 REF.n26 27.1064
R61 REF.n79 REF.n24 27.1064
R62 REF.n84 REF.n22 27.1064
R63 REF.n89 REF.n20 27.1064
R64 REF.n94 REF.n18 27.1064
R65 REF.n99 REF.n16 27.1064
R66 REF.n104 REF.n14 27.1064
R67 REF.n109 REF.n12 27.1064
R68 REF.n71 REF.n70 27.1064
R69 REF.n66 REF.n65 27.1064
R70 REF.n61 REF.n60 27.1064
R71 REF.n48 REF.n47 27.1064
R72 REF.n43 REF.n42 27.1064
R73 REF.n126 REF.n125 27.1064
R74 REF.n121 REF.n120 27.1064
R75 REF.n114 REF.n10 27.1064
R76 REF.n75 REF.t16 24.1005
R77 REF.n80 REF.t17 24.1005
R78 REF.n85 REF.t10 24.1005
R79 REF.n90 REF.t2 24.1005
R80 REF.n95 REF.t8 24.1005
R81 REF.n100 REF.t4 24.1005
R82 REF.n105 REF.t18 24.1005
R83 REF.n110 REF.t19 24.1005
R84 REF.n28 REF.t20 24.1005
R85 REF.n30 REF.t21 24.1005
R86 REF.n32 REF.t0 24.1005
R87 REF.n34 REF.t14 24.1005
R88 REF.n36 REF.t6 24.1005
R89 REF.n6 REF.t12 24.1005
R90 REF.n8 REF.t22 24.1005
R91 REF.n115 REF.t23 24.1005
R92 REF.n77 REF.n76 23.0638
R93 REF.n82 REF.n81 23.0638
R94 REF.n87 REF.n86 23.0638
R95 REF.n92 REF.n91 23.0638
R96 REF.n97 REF.n96 23.0638
R97 REF.n102 REF.n101 23.0638
R98 REF.n107 REF.n106 23.0638
R99 REF.n112 REF.n111 23.0638
R100 REF.n69 REF.n68 23.0638
R101 REF.n64 REF.n63 23.0638
R102 REF.n59 REF.n58 23.0638
R103 REF.n46 REF.n45 23.0638
R104 REF.n41 REF.n40 23.0638
R105 REF.n124 REF.n123 23.0638
R106 REF.n119 REF.n118 23.0638
R107 REF.n117 REF.n116 23.0638
R108 REF.n76 REF.n26 11.3247
R109 REF.n81 REF.n24 11.3247
R110 REF.n86 REF.n22 11.3247
R111 REF.n91 REF.n20 11.3247
R112 REF.n96 REF.n18 11.3247
R113 REF.n101 REF.n16 11.3247
R114 REF.n106 REF.n14 11.3247
R115 REF.n111 REF.n12 11.3247
R116 REF.n70 REF.n69 11.3247
R117 REF.n65 REF.n64 11.3247
R118 REF.n60 REF.n59 11.3247
R119 REF.n47 REF.n46 11.3247
R120 REF.n42 REF.n41 11.3247
R121 REF.n125 REF.n124 11.3247
R122 REF.n120 REF.n119 11.3247
R123 REF.n116 REF.n10 11.3247
R124 REF.n114 REF.n113 9.3005
R125 REF.n10 REF.n9 9.3005
R126 REF.n122 REF.n121 9.3005
R127 REF.n120 REF.n7 9.3005
R128 REF.n127 REF.n126 9.3005
R129 REF.n125 REF.n5 9.3005
R130 REF.n44 REF.n43 9.3005
R131 REF.n42 REF.n35 9.3005
R132 REF.n49 REF.n48 9.3005
R133 REF.n47 REF.n33 9.3005
R134 REF.n62 REF.n61 9.3005
R135 REF.n60 REF.n31 9.3005
R136 REF.n67 REF.n66 9.3005
R137 REF.n65 REF.n29 9.3005
R138 REF.n72 REF.n71 9.3005
R139 REF.n70 REF.n27 9.3005
R140 REF.n109 REF.n108 9.3005
R141 REF.n12 REF.n11 9.3005
R142 REF.n104 REF.n103 9.3005
R143 REF.n14 REF.n13 9.3005
R144 REF.n99 REF.n98 9.3005
R145 REF.n16 REF.n15 9.3005
R146 REF.n94 REF.n93 9.3005
R147 REF.n18 REF.n17 9.3005
R148 REF.n89 REF.n88 9.3005
R149 REF.n20 REF.n19 9.3005
R150 REF.n84 REF.n83 9.3005
R151 REF.n22 REF.n21 9.3005
R152 REF.n79 REF.n78 9.3005
R153 REF.n24 REF.n23 9.3005
R154 REF.n74 REF.n73 9.3005
R155 REF.n26 REF.n25 9.3005
R156 REF.n129 REF.n128 4.54595
R157 REF.n39 REF.n38 4.54595
R158 REF.n54 REF.n50 4.5005
R159 REF.n57 REF.n56 4.5005
R160 REF.n37 REF.n4 4.5005
R161 REF.n56 REF.n51 3.48262
R162 REF.n54 REF.n51 3.42565
R163 REF.n38 REF.n0 3.4105
R164 REF.n130 REF.n129 3.4105
R165 REF REF.n130 1.20826
R166 REF.n73 REF.n72 0.382056
R167 REF.n113 REF.n112 0.382056
R168 REF.n51 REF.n0 0.354424
R169 REF.n118 REF.n117 0.295955
R170 REF.n123 REF.n122 0.295955
R171 REF.n45 REF.n44 0.295955
R172 REF.n63 REF.n62 0.295955
R173 REF.n68 REF.n67 0.295955
R174 REF.n108 REF.n107 0.295955
R175 REF.n103 REF.n102 0.295955
R176 REF.n98 REF.n97 0.295955
R177 REF.n93 REF.n92 0.295955
R178 REF.n88 REF.n87 0.295955
R179 REF.n83 REF.n82 0.295955
R180 REF.n78 REF.n77 0.295955
R181 REF.n113 REF.n9 0.136864
R182 REF.n117 REF.n9 0.136864
R183 REF.n118 REF.n7 0.136864
R184 REF.n122 REF.n7 0.136864
R185 REF.n123 REF.n5 0.136864
R186 REF.n127 REF.n5 0.136864
R187 REF.n40 REF.n35 0.136864
R188 REF.n44 REF.n35 0.136864
R189 REF.n45 REF.n33 0.136864
R190 REF.n49 REF.n33 0.136864
R191 REF.n58 REF.n31 0.136864
R192 REF.n62 REF.n31 0.136864
R193 REF.n63 REF.n29 0.136864
R194 REF.n67 REF.n29 0.136864
R195 REF.n68 REF.n27 0.136864
R196 REF.n72 REF.n27 0.136864
R197 REF.n112 REF.n11 0.136864
R198 REF.n108 REF.n11 0.136864
R199 REF.n107 REF.n13 0.136864
R200 REF.n103 REF.n13 0.136864
R201 REF.n102 REF.n15 0.136864
R202 REF.n98 REF.n15 0.136864
R203 REF.n97 REF.n17 0.136864
R204 REF.n93 REF.n17 0.136864
R205 REF.n92 REF.n19 0.136864
R206 REF.n88 REF.n19 0.136864
R207 REF.n87 REF.n21 0.136864
R208 REF.n83 REF.n21 0.136864
R209 REF.n82 REF.n23 0.136864
R210 REF.n78 REF.n23 0.136864
R211 REF.n77 REF.n25 0.136864
R212 REF.n73 REF.n25 0.136864
R213 REF.n128 REF.n4 0.121712
R214 REF.n39 REF.n4 0.121712
R215 REF.n57 REF.n50 0.121712
R216 REF.n58 REF.n57 0.117924
R217 REF.n55 REF.n54 0.0914091
R218 REF.n38 REF.n37 0.0762576
R219 REF.n129 REF.n3 0.063
R220 REF.n130 REF.n0 0.0574697
R221 REF.n50 REF.n49 0.0573182
R222 REF.n128 REF.n127 0.0402727
R223 REF.n56 REF.n55 0.030803
R224 REF.n40 REF.n39 0.0137576
R225 REF.n37 REF.n3 0.0137576
R226 VGND.n174 VGND.n173 585
R227 VGND.n175 VGND.n174 585
R228 VGND.n209 VGND.n208 585
R229 VGND.n206 VGND.n177 585
R230 VGND.n205 VGND.n204 585
R231 VGND.n198 VGND.n179 585
R232 VGND.n199 VGND.n173 585
R233 VGND.n200 VGND.n199 585
R234 VGND.n197 VGND.n181 585
R235 VGND.n195 VGND.n194 585
R236 VGND.n183 VGND.n182 585
R237 VGND.n190 VGND.n189 585
R238 VGND.n187 VGND.n185 585
R239 VGND.n172 VGND.n171 585
R240 VGND.n215 VGND.n214 585
R241 VGND.n214 VGND.n213 585
R242 VGND.n167 VGND.n166 585
R243 VGND.n166 VGND.n165 585
R244 VGND.n224 VGND.n223 585
R245 VGND.n225 VGND.n224 585
R246 VGND.n162 VGND.n161 585
R247 VGND.n163 VGND.n162 585
R248 VGND.n253 VGND.n252 585
R249 VGND.n252 VGND.n251 585
R250 VGND.n155 VGND.n154 585
R251 VGND.n154 VGND.n153 585
R252 VGND.n262 VGND.n261 585
R253 VGND.n263 VGND.n262 585
R254 VGND.n150 VGND.n149 585
R255 VGND.n151 VGND.n150 585
R256 VGND.n273 VGND.n272 585
R257 VGND.n272 VGND.n271 585
R258 VGND.n143 VGND.n142 585
R259 VGND.n142 VGND.n141 585
R260 VGND.n282 VGND.n281 585
R261 VGND.n283 VGND.n282 585
R262 VGND.n138 VGND.n137 585
R263 VGND.n139 VGND.n138 585
R264 VGND.n293 VGND.n292 585
R265 VGND.n292 VGND.n291 585
R266 VGND.n131 VGND.n130 585
R267 VGND.n130 VGND.n129 585
R268 VGND.n302 VGND.n301 585
R269 VGND.n303 VGND.n302 585
R270 VGND.n126 VGND.n125 585
R271 VGND.n127 VGND.n126 585
R272 VGND.n309 VGND.n308 585
R273 VGND.n308 VGND.n307 585
R274 VGND.n119 VGND.n118 585
R275 VGND.n118 VGND.n117 585
R276 VGND.n318 VGND.n317 585
R277 VGND.n319 VGND.n318 585
R278 VGND.n114 VGND.n113 585
R279 VGND.n115 VGND.n114 585
R280 VGND.n329 VGND.n328 585
R281 VGND.n328 VGND.n327 585
R282 VGND.n107 VGND.n106 585
R283 VGND.n106 VGND.n105 585
R284 VGND.n338 VGND.n337 585
R285 VGND.n339 VGND.n338 585
R286 VGND.n102 VGND.n101 585
R287 VGND.n103 VGND.n102 585
R288 VGND.n345 VGND.n344 585
R289 VGND.n344 VGND.n343 585
R290 VGND.t39 VGND.n95 585
R291 VGND.n95 VGND.n94 585
R292 VGND.n354 VGND.n353 585
R293 VGND.n355 VGND.n354 585
R294 VGND.n91 VGND.n90 585
R295 VGND.n92 VGND.n91 585
R296 VGND.n366 VGND.n364 585
R297 VGND.n364 VGND.n363 585
R298 VGND.n365 VGND.n84 585
R299 VGND.n84 VGND.n83 585
R300 VGND.n375 VGND.n374 585
R301 VGND.n376 VGND.n375 585
R302 VGND.n80 VGND.n79 585
R303 VGND.n81 VGND.n80 585
R304 VGND.n383 VGND.n381 585
R305 VGND.n381 VGND.n380 585
R306 VGND.n382 VGND.n73 585
R307 VGND.n73 VGND.n72 585
R308 VGND.n392 VGND.n391 585
R309 VGND.n393 VGND.n392 585
R310 VGND.n69 VGND.n68 585
R311 VGND.n70 VGND.n69 585
R312 VGND.n404 VGND.n402 585
R313 VGND.n402 VGND.n401 585
R314 VGND.n403 VGND.n62 585
R315 VGND.n62 VGND.n61 585
R316 VGND.n413 VGND.n412 585
R317 VGND.n414 VGND.n413 585
R318 VGND.n58 VGND.n57 585
R319 VGND.n59 VGND.n58 585
R320 VGND.n421 VGND.n419 585
R321 VGND.n419 VGND.n418 585
R322 VGND.n420 VGND.n51 585
R323 VGND.n51 VGND.n50 585
R324 VGND.n430 VGND.n429 585
R325 VGND.n431 VGND.n430 585
R326 VGND.n47 VGND.n46 585
R327 VGND.n48 VGND.n47 585
R328 VGND.n442 VGND.n440 585
R329 VGND.n440 VGND.n439 585
R330 VGND.n441 VGND.n40 585
R331 VGND.n40 VGND.n39 585
R332 VGND.n451 VGND.n450 585
R333 VGND.n452 VGND.n451 585
R334 VGND.n36 VGND.n35 585
R335 VGND.n37 VGND.n36 585
R336 VGND.n462 VGND.n461 585
R337 VGND.n461 VGND.n460 585
R338 VGND.n26 VGND.n25 585
R339 VGND.n25 VGND.n24 585
R340 VGND.n473 VGND.t1 585
R341 VGND.n474 VGND.n473 585
R342 VGND.n27 VGND.n21 585
R343 VGND.n22 VGND.n21 585
R344 VGND.n501 VGND.n20 585
R345 VGND.n501 VGND.n500 585
R346 VGND.n503 VGND.n502 585
R347 VGND.n502 VGND.n2 585
R348 VGND.n6 VGND.n3 585
R349 VGND.n538 VGND.n3 585
R350 VGND.n505 VGND.n16 585
R351 VGND.n512 VGND.n511 585
R352 VGND.n514 VGND.n513 585
R353 VGND.n517 VGND.n516 585
R354 VGND.n515 VGND.n14 585
R355 VGND.n522 VGND.n521 585
R356 VGND.n524 VGND.n523 585
R357 VGND.n526 VGND.n525 585
R358 VGND.n12 VGND.n11 585
R359 VGND.n532 VGND.n531 585
R360 VGND.n5 VGND.n4 585
R361 VGND.n537 VGND.n536 585
R362 VGND.n506 VGND.n6 585
R363 VGND.n507 VGND.n506 585
R364 VGND.n504 VGND.n503 585
R365 VGND.n504 VGND.n18 585
R366 VGND.n20 VGND.n19 585
R367 VGND.n467 VGND.n19 585
R368 VGND.n29 VGND.n27 585
R369 VGND.n31 VGND.n29 585
R370 VGND.t1 VGND.n472 585
R371 VGND.n472 VGND.n471 585
R372 VGND.n28 VGND.n26 585
R373 VGND.n30 VGND.n28 585
R374 VGND.n463 VGND.n462 585
R375 VGND.n464 VGND.n463 585
R376 VGND.n35 VGND.n34 585
R377 VGND.n34 VGND.n33 585
R378 VGND.n450 VGND.n449 585
R379 VGND.n449 VGND.n448 585
R380 VGND.n441 VGND.n41 585
R381 VGND.n42 VGND.n41 585
R382 VGND.n443 VGND.n442 585
R383 VGND.n444 VGND.n443 585
R384 VGND.n46 VGND.n45 585
R385 VGND.n45 VGND.n44 585
R386 VGND.n429 VGND.n428 585
R387 VGND.n428 VGND.n427 585
R388 VGND.n420 VGND.n52 585
R389 VGND.n53 VGND.n52 585
R390 VGND.n422 VGND.n421 585
R391 VGND.n423 VGND.n422 585
R392 VGND.n57 VGND.n56 585
R393 VGND.n56 VGND.n55 585
R394 VGND.n412 VGND.n411 585
R395 VGND.n411 VGND.n410 585
R396 VGND.n403 VGND.n63 585
R397 VGND.n64 VGND.n63 585
R398 VGND.n405 VGND.n404 585
R399 VGND.n406 VGND.n405 585
R400 VGND.n68 VGND.n67 585
R401 VGND.n67 VGND.n66 585
R402 VGND.n391 VGND.n390 585
R403 VGND.n390 VGND.n389 585
R404 VGND.n382 VGND.n74 585
R405 VGND.n75 VGND.n74 585
R406 VGND.n384 VGND.n383 585
R407 VGND.n385 VGND.n384 585
R408 VGND.n79 VGND.n78 585
R409 VGND.n78 VGND.n77 585
R410 VGND.n374 VGND.n373 585
R411 VGND.n373 VGND.n372 585
R412 VGND.n365 VGND.n85 585
R413 VGND.n86 VGND.n85 585
R414 VGND.n367 VGND.n366 585
R415 VGND.n368 VGND.n367 585
R416 VGND.n90 VGND.n89 585
R417 VGND.n89 VGND.n88 585
R418 VGND.n353 VGND.n352 585
R419 VGND.n352 VGND.n351 585
R420 VGND.n96 VGND.t39 585
R421 VGND.n97 VGND.n96 585
R422 VGND.n346 VGND.n345 585
R423 VGND.n347 VGND.n346 585
R424 VGND.n101 VGND.n100 585
R425 VGND.n100 VGND.n99 585
R426 VGND.n337 VGND.n336 585
R427 VGND.n336 VGND.n335 585
R428 VGND.n108 VGND.n107 585
R429 VGND.n109 VGND.n108 585
R430 VGND.n330 VGND.n329 585
R431 VGND.n331 VGND.n330 585
R432 VGND.n113 VGND.n112 585
R433 VGND.n112 VGND.n111 585
R434 VGND.n317 VGND.n316 585
R435 VGND.n316 VGND.n315 585
R436 VGND.n120 VGND.n119 585
R437 VGND.n121 VGND.n120 585
R438 VGND.n310 VGND.n309 585
R439 VGND.n311 VGND.n310 585
R440 VGND.n125 VGND.n124 585
R441 VGND.n124 VGND.n123 585
R442 VGND.n301 VGND.n300 585
R443 VGND.n300 VGND.n299 585
R444 VGND.n132 VGND.n131 585
R445 VGND.n133 VGND.n132 585
R446 VGND.n294 VGND.n293 585
R447 VGND.n295 VGND.n294 585
R448 VGND.n137 VGND.n136 585
R449 VGND.n136 VGND.n135 585
R450 VGND.n281 VGND.n280 585
R451 VGND.n280 VGND.n279 585
R452 VGND.n144 VGND.n143 585
R453 VGND.n145 VGND.n144 585
R454 VGND.n274 VGND.n273 585
R455 VGND.n275 VGND.n274 585
R456 VGND.n149 VGND.n148 585
R457 VGND.n148 VGND.n147 585
R458 VGND.n261 VGND.n260 585
R459 VGND.n260 VGND.n259 585
R460 VGND.n156 VGND.n155 585
R461 VGND.n157 VGND.n156 585
R462 VGND.n254 VGND.n253 585
R463 VGND.n255 VGND.n254 585
R464 VGND.n161 VGND.n160 585
R465 VGND.n160 VGND.n159 585
R466 VGND.n223 VGND.n222 585
R467 VGND.n222 VGND.n221 585
R468 VGND.n168 VGND.n167 585
R469 VGND.n169 VGND.n168 585
R470 VGND.n216 VGND.n215 585
R471 VGND.n217 VGND.n216 585
R472 VGND.n503 VGND.n6 261.387
R473 VGND.n503 VGND.n20 261.387
R474 VGND.n27 VGND.n20 261.387
R475 VGND.t1 VGND.n27 261.387
R476 VGND.t1 VGND.n26 261.387
R477 VGND.n462 VGND.n26 261.387
R478 VGND.n462 VGND.n35 261.387
R479 VGND.n450 VGND.n35 261.387
R480 VGND.n442 VGND.n441 261.387
R481 VGND.n442 VGND.n46 261.387
R482 VGND.n429 VGND.n46 261.387
R483 VGND.n421 VGND.n420 261.387
R484 VGND.n421 VGND.n57 261.387
R485 VGND.n412 VGND.n57 261.387
R486 VGND.n404 VGND.n403 261.387
R487 VGND.n404 VGND.n68 261.387
R488 VGND.n391 VGND.n68 261.387
R489 VGND.n383 VGND.n382 261.387
R490 VGND.n383 VGND.n79 261.387
R491 VGND.n374 VGND.n79 261.387
R492 VGND.n366 VGND.n365 261.387
R493 VGND.n366 VGND.n90 261.387
R494 VGND.n353 VGND.n90 261.387
R495 VGND.n353 VGND.t39 261.387
R496 VGND.n345 VGND.t39 261.387
R497 VGND.n345 VGND.n101 261.387
R498 VGND.n337 VGND.n101 261.387
R499 VGND.n337 VGND.n107 261.387
R500 VGND.n329 VGND.n113 261.387
R501 VGND.n317 VGND.n113 261.387
R502 VGND.n317 VGND.n119 261.387
R503 VGND.n309 VGND.n125 261.387
R504 VGND.n301 VGND.n125 261.387
R505 VGND.n301 VGND.n131 261.387
R506 VGND.n293 VGND.n137 261.387
R507 VGND.n281 VGND.n137 261.387
R508 VGND.n281 VGND.n143 261.387
R509 VGND.n273 VGND.n149 261.387
R510 VGND.n261 VGND.n149 261.387
R511 VGND.n261 VGND.n155 261.387
R512 VGND.n253 VGND.n161 261.387
R513 VGND.n223 VGND.n161 261.387
R514 VGND.n223 VGND.n167 261.387
R515 VGND.n215 VGND.n167 261.387
R516 VGND.n207 VGND.n173 260.875
R517 VGND.n178 VGND.n173 260.875
R518 VGND.n196 VGND.n173 260.875
R519 VGND.n188 VGND.n173 260.875
R520 VGND.n186 VGND.n173 260.875
R521 VGND.n534 VGND.n7 260.875
R522 VGND.n534 VGND.n8 260.875
R523 VGND.n534 VGND.n9 260.875
R524 VGND.n534 VGND.n10 260.875
R525 VGND.n534 VGND.n533 260.875
R526 VGND.n535 VGND.n534 260.875
R527 VGND.n441 VGND.t5 217.822
R528 VGND.n374 VGND.t37 217.822
R529 VGND.n329 VGND.t41 217.822
R530 VGND.t13 VGND.n155 217.822
R531 VGND.n216 VGND.n172 197
R532 VGND.n214 VGND.n174 197
R533 VGND.n536 VGND.n3 197
R534 VGND.n506 VGND.n505 197
R535 VGND.n240 VGND.n238 184.74
R536 VGND.n230 VGND.n228 184.74
R537 VGND.n492 VGND.n491 184.74
R538 VGND.n482 VGND.n481 184.74
R539 VGND.n420 VGND.t28 174.257
R540 VGND.n391 VGND.t35 174.257
R541 VGND.n309 VGND.t32 174.257
R542 VGND.t9 VGND.n143 174.257
R543 VGND.n506 VGND.n504 141.84
R544 VGND.n504 VGND.n19 141.84
R545 VGND.n29 VGND.n19 141.84
R546 VGND.n472 VGND.n29 141.84
R547 VGND.n472 VGND.n28 141.84
R548 VGND.n463 VGND.n28 141.84
R549 VGND.n463 VGND.n34 141.84
R550 VGND.n449 VGND.n34 141.84
R551 VGND.n449 VGND.n41 141.84
R552 VGND.n443 VGND.n41 141.84
R553 VGND.n443 VGND.n45 141.84
R554 VGND.n428 VGND.n45 141.84
R555 VGND.n428 VGND.n52 141.84
R556 VGND.n422 VGND.n52 141.84
R557 VGND.n422 VGND.n56 141.84
R558 VGND.n411 VGND.n56 141.84
R559 VGND.n411 VGND.n63 141.84
R560 VGND.n405 VGND.n63 141.84
R561 VGND.n405 VGND.n67 141.84
R562 VGND.n390 VGND.n67 141.84
R563 VGND.n390 VGND.n74 141.84
R564 VGND.n384 VGND.n74 141.84
R565 VGND.n384 VGND.n78 141.84
R566 VGND.n373 VGND.n78 141.84
R567 VGND.n373 VGND.n85 141.84
R568 VGND.n367 VGND.n85 141.84
R569 VGND.n367 VGND.n89 141.84
R570 VGND.n352 VGND.n89 141.84
R571 VGND.n352 VGND.n96 141.84
R572 VGND.n346 VGND.n96 141.84
R573 VGND.n346 VGND.n100 141.84
R574 VGND.n336 VGND.n100 141.84
R575 VGND.n336 VGND.n108 141.84
R576 VGND.n330 VGND.n108 141.84
R577 VGND.n330 VGND.n112 141.84
R578 VGND.n316 VGND.n112 141.84
R579 VGND.n316 VGND.n120 141.84
R580 VGND.n310 VGND.n120 141.84
R581 VGND.n310 VGND.n124 141.84
R582 VGND.n300 VGND.n124 141.84
R583 VGND.n300 VGND.n132 141.84
R584 VGND.n294 VGND.n132 141.84
R585 VGND.n294 VGND.n136 141.84
R586 VGND.n280 VGND.n136 141.84
R587 VGND.n280 VGND.n144 141.84
R588 VGND.n274 VGND.n144 141.84
R589 VGND.n274 VGND.n148 141.84
R590 VGND.n260 VGND.n148 141.84
R591 VGND.n260 VGND.n156 141.84
R592 VGND.n254 VGND.n156 141.84
R593 VGND.n254 VGND.n160 141.84
R594 VGND.n222 VGND.n160 141.84
R595 VGND.n222 VGND.n168 141.84
R596 VGND.n216 VGND.n168 141.84
R597 VGND.n208 VGND.n174 141.84
R598 VGND.n206 VGND.n205 141.84
R599 VGND.n199 VGND.n198 141.84
R600 VGND.n199 VGND.n197 141.84
R601 VGND.n195 VGND.n182 141.84
R602 VGND.n189 VGND.n187 141.84
R603 VGND.n502 VGND.n3 141.84
R604 VGND.n502 VGND.n501 141.84
R605 VGND.n501 VGND.n21 141.84
R606 VGND.n473 VGND.n21 141.84
R607 VGND.n473 VGND.n25 141.84
R608 VGND.n461 VGND.n25 141.84
R609 VGND.n461 VGND.n36 141.84
R610 VGND.n451 VGND.n36 141.84
R611 VGND.n451 VGND.n40 141.84
R612 VGND.n440 VGND.n40 141.84
R613 VGND.n440 VGND.n47 141.84
R614 VGND.n430 VGND.n47 141.84
R615 VGND.n430 VGND.n51 141.84
R616 VGND.n419 VGND.n51 141.84
R617 VGND.n419 VGND.n58 141.84
R618 VGND.n413 VGND.n58 141.84
R619 VGND.n413 VGND.n62 141.84
R620 VGND.n402 VGND.n62 141.84
R621 VGND.n402 VGND.n69 141.84
R622 VGND.n392 VGND.n69 141.84
R623 VGND.n392 VGND.n73 141.84
R624 VGND.n381 VGND.n73 141.84
R625 VGND.n381 VGND.n80 141.84
R626 VGND.n375 VGND.n80 141.84
R627 VGND.n375 VGND.n84 141.84
R628 VGND.n364 VGND.n84 141.84
R629 VGND.n364 VGND.n91 141.84
R630 VGND.n354 VGND.n91 141.84
R631 VGND.n354 VGND.n95 141.84
R632 VGND.n344 VGND.n95 141.84
R633 VGND.n344 VGND.n102 141.84
R634 VGND.n338 VGND.n102 141.84
R635 VGND.n338 VGND.n106 141.84
R636 VGND.n328 VGND.n106 141.84
R637 VGND.n328 VGND.n114 141.84
R638 VGND.n318 VGND.n114 141.84
R639 VGND.n318 VGND.n118 141.84
R640 VGND.n308 VGND.n118 141.84
R641 VGND.n308 VGND.n126 141.84
R642 VGND.n302 VGND.n126 141.84
R643 VGND.n302 VGND.n130 141.84
R644 VGND.n292 VGND.n130 141.84
R645 VGND.n292 VGND.n138 141.84
R646 VGND.n282 VGND.n138 141.84
R647 VGND.n282 VGND.n142 141.84
R648 VGND.n272 VGND.n142 141.84
R649 VGND.n272 VGND.n150 141.84
R650 VGND.n262 VGND.n150 141.84
R651 VGND.n262 VGND.n154 141.84
R652 VGND.n252 VGND.n154 141.84
R653 VGND.n252 VGND.n162 141.84
R654 VGND.n224 VGND.n162 141.84
R655 VGND.n224 VGND.n166 141.84
R656 VGND.n214 VGND.n166 141.84
R657 VGND.n532 VGND.n5 141.84
R658 VGND.n525 VGND.n11 141.84
R659 VGND.n523 VGND.n522 141.84
R660 VGND.n516 VGND.n515 141.84
R661 VGND.n513 VGND.n512 141.84
R662 VGND.n412 VGND.t30 130.694
R663 VGND.n403 VGND.t30 130.694
R664 VGND.t43 VGND.n131 130.694
R665 VGND.n293 VGND.t43 130.694
R666 VGND.n236 VGND.t14 129.722
R667 VGND.n486 VGND.t3 129.722
R668 VGND.n247 VGND.t26 129.369
R669 VGND.n497 VGND.t18 129.369
R670 VGND.n267 VGND.n265 100.728
R671 VGND.n287 VGND.n285 100.728
R672 VGND.n323 VGND.n321 100.728
R673 VGND.n360 VGND.n358 100.728
R674 VGND.n398 VGND.n396 100.728
R675 VGND.n436 VGND.n434 100.728
R676 VGND.n457 VGND.n455 100.728
R677 VGND.n267 VGND.n266 99.3695
R678 VGND.n287 VGND.n286 99.3695
R679 VGND.n323 VGND.n322 99.3695
R680 VGND.n360 VGND.n359 99.3695
R681 VGND.n398 VGND.n397 99.3695
R682 VGND.n436 VGND.n435 99.3695
R683 VGND.n457 VGND.n456 99.3695
R684 VGND.n429 VGND.t28 87.1292
R685 VGND.n382 VGND.t35 87.1292
R686 VGND.t32 VGND.n119 87.1292
R687 VGND.n273 VGND.t9 87.1292
R688 VGND.n239 VGND.t22 85.143
R689 VGND.n229 VGND.t8 85.1428
R690 VGND.n480 VGND.t4 85.1427
R691 VGND.n490 VGND.t19 85.1427
R692 VGND.n241 VGND.n240 77.1778
R693 VGND.n231 VGND.n230 77.1778
R694 VGND.n493 VGND.n492 77.1778
R695 VGND.n483 VGND.n482 77.1778
R696 VGND.n208 VGND.n207 63.2529
R697 VGND.n198 VGND.n178 63.2529
R698 VGND.n197 VGND.n196 63.2529
R699 VGND.n189 VGND.n188 63.2529
R700 VGND.n187 VGND.n186 63.2529
R701 VGND.n505 VGND.n7 63.2529
R702 VGND.n513 VGND.n8 63.2529
R703 VGND.n515 VGND.n9 63.2529
R704 VGND.n523 VGND.n10 63.2529
R705 VGND.n533 VGND.n11 63.2529
R706 VGND.n535 VGND.n5 63.2529
R707 VGND.n207 VGND.n206 63.2529
R708 VGND.n205 VGND.n178 63.2529
R709 VGND.n196 VGND.n195 63.2529
R710 VGND.n188 VGND.n182 63.2529
R711 VGND.n186 VGND.n172 63.2529
R712 VGND.n536 VGND.n535 63.2529
R713 VGND.n533 VGND.n532 63.2529
R714 VGND.n525 VGND.n10 63.2529
R715 VGND.n522 VGND.n9 63.2529
R716 VGND.n516 VGND.n8 63.2529
R717 VGND.n512 VGND.n7 63.2529
R718 VGND.n534 VGND.n6 58.0863
R719 VGND.n215 VGND.n173 58.0863
R720 VGND.n450 VGND.t5 43.5649
R721 VGND.n365 VGND.t37 43.5649
R722 VGND.t41 VGND.n107 43.5649
R723 VGND.n253 VGND.t13 43.5649
R724 VGND.n266 VGND.t23 30.0005
R725 VGND.n266 VGND.t27 30.0005
R726 VGND.n265 VGND.t10 30.0005
R727 VGND.n265 VGND.t15 30.0005
R728 VGND.n286 VGND.t51 30.0005
R729 VGND.n286 VGND.t24 30.0005
R730 VGND.n285 VGND.t44 30.0005
R731 VGND.n285 VGND.t11 30.0005
R732 VGND.n322 VGND.t50 30.0005
R733 VGND.n322 VGND.t46 30.0005
R734 VGND.n321 VGND.t42 30.0005
R735 VGND.n321 VGND.t33 30.0005
R736 VGND.n359 VGND.t48 30.0005
R737 VGND.n359 VGND.t49 30.0005
R738 VGND.n358 VGND.t38 30.0005
R739 VGND.n358 VGND.t40 30.0005
R740 VGND.n397 VGND.t45 30.0005
R741 VGND.n397 VGND.t47 30.0005
R742 VGND.n396 VGND.t31 30.0005
R743 VGND.n396 VGND.t36 30.0005
R744 VGND.n435 VGND.t20 30.0005
R745 VGND.n435 VGND.t34 30.0005
R746 VGND.n434 VGND.t6 30.0005
R747 VGND.n434 VGND.t29 30.0005
R748 VGND.n456 VGND.t17 30.0005
R749 VGND.n456 VGND.t21 30.0005
R750 VGND.n455 VGND.t2 30.0005
R751 VGND.n455 VGND.t7 30.0005
R752 VGND.n242 VGND.n238 27.1064
R753 VGND.n232 VGND.n228 27.1064
R754 VGND.n491 VGND.n489 27.1064
R755 VGND.n481 VGND.n479 27.1064
R756 VGND.n240 VGND.t25 24.1005
R757 VGND.n230 VGND.t12 24.1005
R758 VGND.n492 VGND.t16 24.1005
R759 VGND.n482 VGND.t0 24.1005
R760 VGND.n484 VGND.n483 23.1599
R761 VGND.n494 VGND.n493 23.1383
R762 VGND.n241 VGND.n239 23.0638
R763 VGND.n231 VGND.n229 23.0638
R764 VGND.n213 VGND.n175 12.8005
R765 VGND.n538 VGND.n537 12.8005
R766 VGND.n507 VGND.n16 12.8005
R767 VGND.n217 VGND.n171 12.8005
R768 VGND.n242 VGND.n241 11.3247
R769 VGND.n232 VGND.n231 11.3247
R770 VGND.n493 VGND.n489 11.3247
R771 VGND.n483 VGND.n479 11.3247
R772 VGND.n244 VGND.n238 9.40387
R773 VGND.n234 VGND.n228 9.39425
R774 VGND.n213 VGND.n212 9.3005
R775 VGND.n165 VGND.n164 9.3005
R776 VGND.n226 VGND.n225 9.3005
R777 VGND.n249 VGND.n163 9.3005
R778 VGND.n251 VGND.n250 9.3005
R779 VGND.n153 VGND.n152 9.3005
R780 VGND.n264 VGND.n263 9.3005
R781 VGND.n269 VGND.n151 9.3005
R782 VGND.n271 VGND.n270 9.3005
R783 VGND.n141 VGND.n140 9.3005
R784 VGND.n284 VGND.n283 9.3005
R785 VGND.n289 VGND.n139 9.3005
R786 VGND.n291 VGND.n290 9.3005
R787 VGND.n129 VGND.n128 9.3005
R788 VGND.n304 VGND.n303 9.3005
R789 VGND.n305 VGND.n127 9.3005
R790 VGND.n307 VGND.n306 9.3005
R791 VGND.n117 VGND.n116 9.3005
R792 VGND.n320 VGND.n319 9.3005
R793 VGND.n325 VGND.n115 9.3005
R794 VGND.n327 VGND.n326 9.3005
R795 VGND.n105 VGND.n104 9.3005
R796 VGND.n340 VGND.n339 9.3005
R797 VGND.n341 VGND.n103 9.3005
R798 VGND.n343 VGND.n342 9.3005
R799 VGND.n94 VGND.n93 9.3005
R800 VGND.n356 VGND.n355 9.3005
R801 VGND.n357 VGND.n92 9.3005
R802 VGND.n363 VGND.n362 9.3005
R803 VGND.n83 VGND.n82 9.3005
R804 VGND.n377 VGND.n376 9.3005
R805 VGND.n378 VGND.n81 9.3005
R806 VGND.n380 VGND.n379 9.3005
R807 VGND.n72 VGND.n71 9.3005
R808 VGND.n394 VGND.n393 9.3005
R809 VGND.n395 VGND.n70 9.3005
R810 VGND.n401 VGND.n400 9.3005
R811 VGND.n61 VGND.n60 9.3005
R812 VGND.n415 VGND.n414 9.3005
R813 VGND.n416 VGND.n59 9.3005
R814 VGND.n418 VGND.n417 9.3005
R815 VGND.n50 VGND.n49 9.3005
R816 VGND.n432 VGND.n431 9.3005
R817 VGND.n433 VGND.n48 9.3005
R818 VGND.n439 VGND.n438 9.3005
R819 VGND.n39 VGND.n38 9.3005
R820 VGND.n453 VGND.n452 9.3005
R821 VGND.n454 VGND.n37 9.3005
R822 VGND.n460 VGND.n459 9.3005
R823 VGND.n24 VGND.n23 9.3005
R824 VGND.n475 VGND.n474 9.3005
R825 VGND.n476 VGND.n22 9.3005
R826 VGND.n500 VGND.n499 9.3005
R827 VGND.n2 VGND.n1 9.3005
R828 VGND.n539 VGND.n538 9.3005
R829 VGND.n509 VGND.n16 9.3005
R830 VGND.n511 VGND.n510 9.3005
R831 VGND.n514 VGND.n15 9.3005
R832 VGND.n518 VGND.n517 9.3005
R833 VGND.n519 VGND.n14 9.3005
R834 VGND.n521 VGND.n520 9.3005
R835 VGND.n524 VGND.n13 9.3005
R836 VGND.n527 VGND.n526 9.3005
R837 VGND.n528 VGND.n12 9.3005
R838 VGND.n531 VGND.n530 9.3005
R839 VGND.n529 VGND.n4 9.3005
R840 VGND.n537 VGND.n0 9.3005
R841 VGND.n508 VGND.n507 9.3005
R842 VGND.n18 VGND.n17 9.3005
R843 VGND.n468 VGND.n467 9.3005
R844 VGND.n469 VGND.n31 9.3005
R845 VGND.n471 VGND.n470 9.3005
R846 VGND.n466 VGND.n30 9.3005
R847 VGND.n465 VGND.n464 9.3005
R848 VGND.n33 VGND.n32 9.3005
R849 VGND.n448 VGND.n447 9.3005
R850 VGND.n446 VGND.n42 9.3005
R851 VGND.n445 VGND.n444 9.3005
R852 VGND.n44 VGND.n43 9.3005
R853 VGND.n427 VGND.n426 9.3005
R854 VGND.n425 VGND.n53 9.3005
R855 VGND.n424 VGND.n423 9.3005
R856 VGND.n55 VGND.n54 9.3005
R857 VGND.n410 VGND.n409 9.3005
R858 VGND.n408 VGND.n64 9.3005
R859 VGND.n407 VGND.n406 9.3005
R860 VGND.n66 VGND.n65 9.3005
R861 VGND.n389 VGND.n388 9.3005
R862 VGND.n387 VGND.n75 9.3005
R863 VGND.n386 VGND.n385 9.3005
R864 VGND.n77 VGND.n76 9.3005
R865 VGND.n372 VGND.n371 9.3005
R866 VGND.n370 VGND.n86 9.3005
R867 VGND.n369 VGND.n368 9.3005
R868 VGND.n88 VGND.n87 9.3005
R869 VGND.n351 VGND.n350 9.3005
R870 VGND.n349 VGND.n97 9.3005
R871 VGND.n348 VGND.n347 9.3005
R872 VGND.n99 VGND.n98 9.3005
R873 VGND.n335 VGND.n334 9.3005
R874 VGND.n333 VGND.n109 9.3005
R875 VGND.n332 VGND.n331 9.3005
R876 VGND.n111 VGND.n110 9.3005
R877 VGND.n315 VGND.n314 9.3005
R878 VGND.n313 VGND.n121 9.3005
R879 VGND.n312 VGND.n311 9.3005
R880 VGND.n123 VGND.n122 9.3005
R881 VGND.n299 VGND.n298 9.3005
R882 VGND.n297 VGND.n133 9.3005
R883 VGND.n296 VGND.n295 9.3005
R884 VGND.n135 VGND.n134 9.3005
R885 VGND.n279 VGND.n278 9.3005
R886 VGND.n277 VGND.n145 9.3005
R887 VGND.n276 VGND.n275 9.3005
R888 VGND.n147 VGND.n146 9.3005
R889 VGND.n259 VGND.n258 9.3005
R890 VGND.n257 VGND.n157 9.3005
R891 VGND.n256 VGND.n255 9.3005
R892 VGND.n159 VGND.n158 9.3005
R893 VGND.n221 VGND.n220 9.3005
R894 VGND.n219 VGND.n169 9.3005
R895 VGND.n218 VGND.n217 9.3005
R896 VGND.n211 VGND.n175 9.3005
R897 VGND.n210 VGND.n209 9.3005
R898 VGND.n177 VGND.n176 9.3005
R899 VGND.n204 VGND.n203 9.3005
R900 VGND.n202 VGND.n179 9.3005
R901 VGND.n201 VGND.n200 9.3005
R902 VGND.n181 VGND.n180 9.3005
R903 VGND.n194 VGND.n193 9.3005
R904 VGND.n192 VGND.n183 9.3005
R905 VGND.n191 VGND.n190 9.3005
R906 VGND.n185 VGND.n184 9.3005
R907 VGND.n171 VGND.n170 9.3005
R908 VGND.n243 VGND.n242 9.3005
R909 VGND.n233 VGND.n232 9.3005
R910 VGND.n491 VGND.n490 9.3005
R911 VGND.n489 VGND.n488 9.3005
R912 VGND.n481 VGND.n480 9.3005
R913 VGND.n479 VGND.n478 9.3005
R914 VGND.n209 VGND.n175 9.2165
R915 VGND.n209 VGND.n177 9.2165
R916 VGND.n204 VGND.n177 9.2165
R917 VGND.n204 VGND.n179 9.2165
R918 VGND.n200 VGND.n179 9.2165
R919 VGND.n200 VGND.n181 9.2165
R920 VGND.n194 VGND.n181 9.2165
R921 VGND.n194 VGND.n183 9.2165
R922 VGND.n190 VGND.n183 9.2165
R923 VGND.n190 VGND.n185 9.2165
R924 VGND.n185 VGND.n171 9.2165
R925 VGND.n538 VGND.n2 9.2165
R926 VGND.n500 VGND.n2 9.2165
R927 VGND.n500 VGND.n22 9.2165
R928 VGND.n474 VGND.n22 9.2165
R929 VGND.n474 VGND.n24 9.2165
R930 VGND.n460 VGND.n24 9.2165
R931 VGND.n460 VGND.n37 9.2165
R932 VGND.n452 VGND.n37 9.2165
R933 VGND.n452 VGND.n39 9.2165
R934 VGND.n439 VGND.n39 9.2165
R935 VGND.n439 VGND.n48 9.2165
R936 VGND.n431 VGND.n48 9.2165
R937 VGND.n431 VGND.n50 9.2165
R938 VGND.n418 VGND.n50 9.2165
R939 VGND.n418 VGND.n59 9.2165
R940 VGND.n414 VGND.n59 9.2165
R941 VGND.n414 VGND.n61 9.2165
R942 VGND.n401 VGND.n61 9.2165
R943 VGND.n401 VGND.n70 9.2165
R944 VGND.n393 VGND.n70 9.2165
R945 VGND.n393 VGND.n72 9.2165
R946 VGND.n380 VGND.n72 9.2165
R947 VGND.n380 VGND.n81 9.2165
R948 VGND.n376 VGND.n81 9.2165
R949 VGND.n376 VGND.n83 9.2165
R950 VGND.n363 VGND.n83 9.2165
R951 VGND.n363 VGND.n92 9.2165
R952 VGND.n355 VGND.n92 9.2165
R953 VGND.n355 VGND.n94 9.2165
R954 VGND.n343 VGND.n94 9.2165
R955 VGND.n343 VGND.n103 9.2165
R956 VGND.n339 VGND.n103 9.2165
R957 VGND.n339 VGND.n105 9.2165
R958 VGND.n327 VGND.n105 9.2165
R959 VGND.n327 VGND.n115 9.2165
R960 VGND.n319 VGND.n115 9.2165
R961 VGND.n319 VGND.n117 9.2165
R962 VGND.n307 VGND.n117 9.2165
R963 VGND.n307 VGND.n127 9.2165
R964 VGND.n303 VGND.n127 9.2165
R965 VGND.n303 VGND.n129 9.2165
R966 VGND.n291 VGND.n129 9.2165
R967 VGND.n291 VGND.n139 9.2165
R968 VGND.n283 VGND.n139 9.2165
R969 VGND.n283 VGND.n141 9.2165
R970 VGND.n271 VGND.n141 9.2165
R971 VGND.n271 VGND.n151 9.2165
R972 VGND.n263 VGND.n151 9.2165
R973 VGND.n263 VGND.n153 9.2165
R974 VGND.n251 VGND.n153 9.2165
R975 VGND.n251 VGND.n163 9.2165
R976 VGND.n225 VGND.n163 9.2165
R977 VGND.n225 VGND.n165 9.2165
R978 VGND.n213 VGND.n165 9.2165
R979 VGND.n537 VGND.n4 9.2165
R980 VGND.n531 VGND.n4 9.2165
R981 VGND.n531 VGND.n12 9.2165
R982 VGND.n526 VGND.n12 9.2165
R983 VGND.n526 VGND.n524 9.2165
R984 VGND.n524 VGND.n521 9.2165
R985 VGND.n521 VGND.n14 9.2165
R986 VGND.n517 VGND.n14 9.2165
R987 VGND.n517 VGND.n514 9.2165
R988 VGND.n514 VGND.n511 9.2165
R989 VGND.n511 VGND.n16 9.2165
R990 VGND.n507 VGND.n18 9.2165
R991 VGND.n467 VGND.n18 9.2165
R992 VGND.n467 VGND.n31 9.2165
R993 VGND.n471 VGND.n31 9.2165
R994 VGND.n471 VGND.n30 9.2165
R995 VGND.n464 VGND.n30 9.2165
R996 VGND.n464 VGND.n33 9.2165
R997 VGND.n448 VGND.n33 9.2165
R998 VGND.n448 VGND.n42 9.2165
R999 VGND.n444 VGND.n42 9.2165
R1000 VGND.n444 VGND.n44 9.2165
R1001 VGND.n427 VGND.n44 9.2165
R1002 VGND.n427 VGND.n53 9.2165
R1003 VGND.n423 VGND.n53 9.2165
R1004 VGND.n423 VGND.n55 9.2165
R1005 VGND.n410 VGND.n55 9.2165
R1006 VGND.n410 VGND.n64 9.2165
R1007 VGND.n406 VGND.n64 9.2165
R1008 VGND.n406 VGND.n66 9.2165
R1009 VGND.n389 VGND.n66 9.2165
R1010 VGND.n389 VGND.n75 9.2165
R1011 VGND.n385 VGND.n75 9.2165
R1012 VGND.n385 VGND.n77 9.2165
R1013 VGND.n372 VGND.n77 9.2165
R1014 VGND.n372 VGND.n86 9.2165
R1015 VGND.n368 VGND.n86 9.2165
R1016 VGND.n368 VGND.n88 9.2165
R1017 VGND.n351 VGND.n88 9.2165
R1018 VGND.n351 VGND.n97 9.2165
R1019 VGND.n347 VGND.n97 9.2165
R1020 VGND.n347 VGND.n99 9.2165
R1021 VGND.n335 VGND.n99 9.2165
R1022 VGND.n335 VGND.n109 9.2165
R1023 VGND.n331 VGND.n109 9.2165
R1024 VGND.n331 VGND.n111 9.2165
R1025 VGND.n315 VGND.n111 9.2165
R1026 VGND.n315 VGND.n121 9.2165
R1027 VGND.n311 VGND.n121 9.2165
R1028 VGND.n311 VGND.n123 9.2165
R1029 VGND.n299 VGND.n123 9.2165
R1030 VGND.n299 VGND.n133 9.2165
R1031 VGND.n295 VGND.n133 9.2165
R1032 VGND.n295 VGND.n135 9.2165
R1033 VGND.n279 VGND.n135 9.2165
R1034 VGND.n279 VGND.n145 9.2165
R1035 VGND.n275 VGND.n145 9.2165
R1036 VGND.n275 VGND.n147 9.2165
R1037 VGND.n259 VGND.n147 9.2165
R1038 VGND.n259 VGND.n157 9.2165
R1039 VGND.n255 VGND.n157 9.2165
R1040 VGND.n255 VGND.n159 9.2165
R1041 VGND.n221 VGND.n159 9.2165
R1042 VGND.n221 VGND.n169 9.2165
R1043 VGND.n217 VGND.n169 9.2165
R1044 VGND.n245 VGND.n237 4.65435
R1045 VGND.n235 VGND.n227 4.65435
R1046 VGND.n495 VGND.n487 4.65435
R1047 VGND.n485 VGND.n477 4.65435
R1048 VGND.n245 VGND.n244 4.5005
R1049 VGND.n235 VGND.n234 4.5005
R1050 VGND.n495 VGND.n494 4.5005
R1051 VGND.n485 VGND.n484 4.5005
R1052 VGND.n498 VGND.n497 1.96555
R1053 VGND.n458 VGND.n457 1.96555
R1054 VGND.n437 VGND.n436 1.96555
R1055 VGND.n399 VGND.n398 1.96555
R1056 VGND.n361 VGND.n360 1.96555
R1057 VGND.n324 VGND.n323 1.96555
R1058 VGND.n288 VGND.n287 1.96555
R1059 VGND.n268 VGND.n267 1.96555
R1060 VGND.n248 VGND.n247 1.96555
R1061 VGND.n246 VGND.n236 0.401942
R1062 VGND.n496 VGND.n486 0.401942
R1063 VGND.n247 VGND.n246 0.355498
R1064 VGND.n497 VGND.n496 0.355498
R1065 VGND.n246 VGND.n245 0.291365
R1066 VGND.n486 VGND.n485 0.284154
R1067 VGND.n236 VGND.n235 0.28175
R1068 VGND.n496 VGND.n495 0.262519
R1069 VGND.n509 VGND.n508 0.1255
R1070 VGND.n218 VGND.n170 0.1255
R1071 VGND.n490 VGND.n487 0.118288
R1072 VGND.n229 VGND.n227 0.0990577
R1073 VGND.n494 VGND.n488 0.0990577
R1074 VGND.n480 VGND.n477 0.0966538
R1075 VGND.n529 VGND.n0 0.0905
R1076 VGND.n530 VGND.n529 0.0905
R1077 VGND.n530 VGND.n528 0.0905
R1078 VGND.n528 VGND.n527 0.0905
R1079 VGND.n527 VGND.n13 0.0905
R1080 VGND.n520 VGND.n13 0.0905
R1081 VGND.n520 VGND.n519 0.0905
R1082 VGND.n519 VGND.n518 0.0905
R1083 VGND.n518 VGND.n15 0.0905
R1084 VGND.n510 VGND.n15 0.0905
R1085 VGND.n510 VGND.n509 0.0905
R1086 VGND.n508 VGND.n17 0.0905
R1087 VGND.n468 VGND.n17 0.0905
R1088 VGND.n469 VGND.n468 0.0905
R1089 VGND.n470 VGND.n469 0.0905
R1090 VGND.n470 VGND.n466 0.0905
R1091 VGND.n466 VGND.n465 0.0905
R1092 VGND.n465 VGND.n32 0.0905
R1093 VGND.n447 VGND.n32 0.0905
R1094 VGND.n447 VGND.n446 0.0905
R1095 VGND.n446 VGND.n445 0.0905
R1096 VGND.n445 VGND.n43 0.0905
R1097 VGND.n426 VGND.n43 0.0905
R1098 VGND.n426 VGND.n425 0.0905
R1099 VGND.n425 VGND.n424 0.0905
R1100 VGND.n424 VGND.n54 0.0905
R1101 VGND.n409 VGND.n54 0.0905
R1102 VGND.n409 VGND.n408 0.0905
R1103 VGND.n408 VGND.n407 0.0905
R1104 VGND.n407 VGND.n65 0.0905
R1105 VGND.n388 VGND.n65 0.0905
R1106 VGND.n388 VGND.n387 0.0905
R1107 VGND.n387 VGND.n386 0.0905
R1108 VGND.n386 VGND.n76 0.0905
R1109 VGND.n371 VGND.n76 0.0905
R1110 VGND.n371 VGND.n370 0.0905
R1111 VGND.n370 VGND.n369 0.0905
R1112 VGND.n369 VGND.n87 0.0905
R1113 VGND.n350 VGND.n87 0.0905
R1114 VGND.n350 VGND.n349 0.0905
R1115 VGND.n349 VGND.n348 0.0905
R1116 VGND.n348 VGND.n98 0.0905
R1117 VGND.n334 VGND.n98 0.0905
R1118 VGND.n334 VGND.n333 0.0905
R1119 VGND.n333 VGND.n332 0.0905
R1120 VGND.n332 VGND.n110 0.0905
R1121 VGND.n314 VGND.n110 0.0905
R1122 VGND.n314 VGND.n313 0.0905
R1123 VGND.n313 VGND.n312 0.0905
R1124 VGND.n312 VGND.n122 0.0905
R1125 VGND.n298 VGND.n122 0.0905
R1126 VGND.n298 VGND.n297 0.0905
R1127 VGND.n297 VGND.n296 0.0905
R1128 VGND.n296 VGND.n134 0.0905
R1129 VGND.n278 VGND.n134 0.0905
R1130 VGND.n278 VGND.n277 0.0905
R1131 VGND.n277 VGND.n276 0.0905
R1132 VGND.n276 VGND.n146 0.0905
R1133 VGND.n258 VGND.n146 0.0905
R1134 VGND.n258 VGND.n257 0.0905
R1135 VGND.n257 VGND.n256 0.0905
R1136 VGND.n256 VGND.n158 0.0905
R1137 VGND.n220 VGND.n158 0.0905
R1138 VGND.n220 VGND.n219 0.0905
R1139 VGND.n219 VGND.n218 0.0905
R1140 VGND.n211 VGND.n210 0.0905
R1141 VGND.n210 VGND.n176 0.0905
R1142 VGND.n203 VGND.n176 0.0905
R1143 VGND.n203 VGND.n202 0.0905
R1144 VGND.n202 VGND.n201 0.0905
R1145 VGND.n201 VGND.n180 0.0905
R1146 VGND.n193 VGND.n180 0.0905
R1147 VGND.n193 VGND.n192 0.0905
R1148 VGND.n192 VGND.n191 0.0905
R1149 VGND.n191 VGND.n184 0.0905
R1150 VGND.n184 VGND.n170 0.0905
R1151 VGND.n239 VGND.n237 0.0894423
R1152 VGND.n243 VGND.n237 0.0846346
R1153 VGND.n234 VGND.n233 0.0798269
R1154 VGND.n484 VGND.n478 0.0774231
R1155 VGND.n478 VGND.n477 0.0774231
R1156 VGND.n233 VGND.n227 0.0750192
R1157 VGND.n244 VGND.n243 0.0702115
R1158 VGND.n488 VGND.n487 0.0557885
R1159 VGND VGND.n540 0.047375
R1160 VGND.n539 VGND.n1 0.0455
R1161 VGND.n499 VGND.n476 0.0455
R1162 VGND.n476 VGND.n475 0.0455
R1163 VGND.n475 VGND.n23 0.0455
R1164 VGND.n459 VGND.n23 0.0455
R1165 VGND.n454 VGND.n453 0.0455
R1166 VGND.n453 VGND.n38 0.0455
R1167 VGND.n438 VGND.n38 0.0455
R1168 VGND.n433 VGND.n432 0.0455
R1169 VGND.n432 VGND.n49 0.0455
R1170 VGND.n417 VGND.n49 0.0455
R1171 VGND.n417 VGND.n416 0.0455
R1172 VGND.n416 VGND.n415 0.0455
R1173 VGND.n415 VGND.n60 0.0455
R1174 VGND.n400 VGND.n60 0.0455
R1175 VGND.n395 VGND.n394 0.0455
R1176 VGND.n394 VGND.n71 0.0455
R1177 VGND.n379 VGND.n71 0.0455
R1178 VGND.n379 VGND.n378 0.0455
R1179 VGND.n378 VGND.n377 0.0455
R1180 VGND.n377 VGND.n82 0.0455
R1181 VGND.n362 VGND.n82 0.0455
R1182 VGND.n357 VGND.n356 0.0455
R1183 VGND.n356 VGND.n93 0.0455
R1184 VGND.n342 VGND.n93 0.0455
R1185 VGND.n342 VGND.n341 0.0455
R1186 VGND.n341 VGND.n340 0.0455
R1187 VGND.n340 VGND.n104 0.0455
R1188 VGND.n326 VGND.n104 0.0455
R1189 VGND.n326 VGND.n325 0.0455
R1190 VGND.n320 VGND.n116 0.0455
R1191 VGND.n306 VGND.n116 0.0455
R1192 VGND.n306 VGND.n305 0.0455
R1193 VGND.n305 VGND.n304 0.0455
R1194 VGND.n304 VGND.n128 0.0455
R1195 VGND.n290 VGND.n128 0.0455
R1196 VGND.n290 VGND.n289 0.0455
R1197 VGND.n284 VGND.n140 0.0455
R1198 VGND.n270 VGND.n140 0.0455
R1199 VGND.n270 VGND.n269 0.0455
R1200 VGND.n264 VGND.n152 0.0455
R1201 VGND.n250 VGND.n152 0.0455
R1202 VGND.n250 VGND.n249 0.0455
R1203 VGND.n226 VGND.n164 0.0455
R1204 VGND.n212 VGND.n164 0.0455
R1205 VGND.n498 VGND.n1 0.04175
R1206 VGND.n458 VGND.n454 0.04175
R1207 VGND.n362 VGND.n361 0.04175
R1208 VGND.n249 VGND.n248 0.04175
R1209 VGND.n437 VGND.n433 0.03425
R1210 VGND.n324 VGND.n320 0.03425
R1211 VGND.n269 VGND.n268 0.03425
R1212 VGND.n400 VGND.n399 0.02675
R1213 VGND.n289 VGND.n288 0.02675
R1214 VGND.n212 VGND.n211 0.02175
R1215 VGND.n399 VGND.n395 0.01925
R1216 VGND.n288 VGND.n284 0.01925
R1217 VGND.n438 VGND.n437 0.01175
R1218 VGND.n325 VGND.n324 0.01175
R1219 VGND.n268 VGND.n264 0.01175
R1220 VGND.n540 VGND.n0 0.01175
R1221 VGND.n540 VGND.n539 0.0105
R1222 VGND.n499 VGND.n498 0.00425
R1223 VGND.n459 VGND.n458 0.00425
R1224 VGND.n361 VGND.n357 0.00425
R1225 VGND.n248 VGND.n226 0.00425
C1 OUT VGND 2.07014f
C2 REF VGND 8.64694f
C3 REF.n0 VGND 0.01629f
C4 REF.t7 VGND 0.00428f
C5 REF.t13 VGND 0.00428f
C6 REF.n1 VGND 0.00902f
C7 REF.t9 VGND 0.00428f
C8 REF.t5 VGND 0.00428f
C9 REF.n2 VGND 0.00914f
C10 REF.n3 VGND 0.04773f
C11 REF.n4 VGND 0.00361f
C12 REF.n5 VGND 0.00407f
C13 REF.t12 VGND 0.03252f
C14 REF.n6 VGND 0.02464f
C15 REF.n7 VGND 0.00407f
C16 REF.t22 VGND 0.03252f
C17 REF.n8 VGND 0.02464f
C18 REF.n9 VGND 0.00407f
C19 REF.n10 VGND 0.00209f
C20 REF.t23 VGND 0.03252f
C21 REF.n11 VGND 0.00407f
C22 REF.n12 VGND 0.00209f
C23 REF.t19 VGND 0.03252f
C24 REF.n13 VGND 0.00407f
C25 REF.n14 VGND 0.00209f
C26 REF.t18 VGND 0.03252f
C27 REF.n15 VGND 0.00407f
C28 REF.n16 VGND 0.00209f
C29 REF.t4 VGND 0.03252f
C30 REF.n17 VGND 0.00407f
C31 REF.n18 VGND 0.00209f
C32 REF.t8 VGND 0.03252f
C33 REF.n19 VGND 0.00407f
C34 REF.n20 VGND 0.00209f
C35 REF.t2 VGND 0.03252f
C36 REF.n21 VGND 0.00407f
C37 REF.n22 VGND 0.00209f
C38 REF.t10 VGND 0.03252f
C39 REF.n23 VGND 0.00407f
C40 REF.n24 VGND 0.00209f
C41 REF.t17 VGND 0.03252f
C42 REF.n25 VGND 0.00407f
C43 REF.n26 VGND 0.00209f
C44 REF.t16 VGND 0.03252f
C45 REF.n27 VGND 0.00407f
C46 REF.t20 VGND 0.03252f
C47 REF.n28 VGND 0.02464f
C48 REF.n29 VGND 0.00407f
C49 REF.t21 VGND 0.03252f
C50 REF.n30 VGND 0.02464f
C51 REF.n31 VGND 0.00407f
C52 REF.t0 VGND 0.03252f
C53 REF.n32 VGND 0.02464f
C54 REF.n33 VGND 0.00407f
C55 REF.t14 VGND 0.03252f
C56 REF.n34 VGND 0.02464f
C57 REF.n35 VGND 0.00407f
C58 REF.t6 VGND 0.03252f
C59 REF.n36 VGND 0.02464f
C60 REF.n37 VGND 0.00133f
C61 REF.n38 VGND 0.00449f
C62 REF.n39 VGND 0.00203f
C63 REF.n40 VGND 0.00404f
C64 REF.n41 VGND 0.00122f
C65 REF.n42 VGND 0.00209f
C66 REF.n43 VGND 0.00304f
C67 REF.n44 VGND 0.00644f
C68 REF.n45 VGND 0.00825f
C69 REF.n46 VGND 0.00122f
C70 REF.n47 VGND 0.00209f
C71 REF.n48 VGND 0.00304f
C72 REF.n49 VGND 0.00288f
C73 REF.n50 VGND 0.00265f
C74 REF.n51 VGND 0.02076f
C75 REF.t1 VGND 0.00428f
C76 REF.t15 VGND 0.00428f
C77 REF.n52 VGND 0.00902f
C78 REF.t11 VGND 0.00428f
C79 REF.t3 VGND 0.00428f
C80 REF.n53 VGND 0.00914f
C81 REF.n54 VGND 0.00406f
C82 REF.n55 VGND 0.0484f
C83 REF.n56 VGND 0.00323f
C84 REF.n57 VGND 0.00356f
C85 REF.n58 VGND 0.0056f
C86 REF.n59 VGND 0.00122f
C87 REF.n60 VGND 0.00209f
C88 REF.n61 VGND 0.00304f
C89 REF.n62 VGND 0.00644f
C90 REF.n63 VGND 0.00825f
C91 REF.n64 VGND 0.00122f
C92 REF.n65 VGND 0.00209f
C93 REF.n66 VGND 0.00304f
C94 REF.n67 VGND 0.00644f
C95 REF.n68 VGND 0.00825f
C96 REF.n69 VGND 0.00122f
C97 REF.n70 VGND 0.00209f
C98 REF.n71 VGND 0.00304f
C99 REF.n72 VGND 0.0071f
C100 REF.n73 VGND 0.0071f
C101 REF.n74 VGND 0.00304f
C102 REF.n75 VGND 0.02464f
C103 REF.n76 VGND 0.00122f
C104 REF.n77 VGND 0.00825f
C105 REF.n78 VGND 0.00644f
C106 REF.n79 VGND 0.00304f
C107 REF.n80 VGND 0.02464f
C108 REF.n81 VGND 0.00122f
C109 REF.n82 VGND 0.00825f
C110 REF.n83 VGND 0.00644f
C111 REF.n84 VGND 0.00304f
C112 REF.n85 VGND 0.02464f
C113 REF.n86 VGND 0.00122f
C114 REF.n87 VGND 0.00825f
C115 REF.n88 VGND 0.00644f
C116 REF.n89 VGND 0.00304f
C117 REF.n90 VGND 0.02464f
C118 REF.n91 VGND 0.00122f
C119 REF.n92 VGND 0.00825f
C120 REF.n93 VGND 0.00644f
C121 REF.n94 VGND 0.00304f
C122 REF.n95 VGND 0.02464f
C123 REF.n96 VGND 0.00122f
C124 REF.n97 VGND 0.00825f
C125 REF.n98 VGND 0.00644f
C126 REF.n99 VGND 0.00304f
C127 REF.n100 VGND 0.02464f
C128 REF.n101 VGND 0.00122f
C129 REF.n102 VGND 0.00825f
C130 REF.n103 VGND 0.00644f
C131 REF.n104 VGND 0.00304f
C132 REF.n105 VGND 0.02464f
C133 REF.n106 VGND 0.00122f
C134 REF.n107 VGND 0.00825f
C135 REF.n108 VGND 0.00644f
C136 REF.n109 VGND 0.00304f
C137 REF.n110 VGND 0.02464f
C138 REF.n111 VGND 0.00122f
C139 REF.n112 VGND 0.00891f
C140 REF.n113 VGND 0.0071f
C141 REF.n114 VGND 0.00304f
C142 REF.n115 VGND 0.02464f
C143 REF.n116 VGND 0.00122f
C144 REF.n117 VGND 0.00825f
C145 REF.n118 VGND 0.00825f
C146 REF.n119 VGND 0.00122f
C147 REF.n120 VGND 0.00209f
C148 REF.n121 VGND 0.00304f
C149 REF.n122 VGND 0.00644f
C150 REF.n123 VGND 0.00825f
C151 REF.n124 VGND 0.00122f
C152 REF.n125 VGND 0.00209f
C153 REF.n126 VGND 0.00304f
C154 REF.n127 VGND 0.00263f
C155 REF.n128 VGND 0.00243f
C156 REF.n129 VGND 0.00429f
C157 REF.n130 VGND 0.05016f
C158 OUT.t6 VGND 0.02006f
C159 OUT.t4 VGND 0.02006f
C160 OUT.n0 VGND 0.04258f
C161 OUT.t3 VGND 0.02006f
C162 OUT.t5 VGND 0.02006f
C163 OUT.n1 VGND 0.04249f
C164 OUT.n2 VGND 0.36001f
C165 OUT.t2 VGND 0.02006f
C166 OUT.t7 VGND 0.02006f
C167 OUT.n3 VGND 0.04258f
C168 OUT.t0 VGND 0.02006f
C169 OUT.t1 VGND 0.02006f
C170 OUT.n4 VGND 0.04249f
C171 OUT.n5 VGND 0.25953f
C172 OUT.n6 VGND 0.52973f
C173 OUT.n7 VGND 0.15835f
