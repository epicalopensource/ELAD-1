* SPICE3 file created from ELAD1_MIRROR_CC_flat.ext - technology: sky130A

X0 REF REF VGND VGND.t28 sky130_fd_pr__nfet_01v8 ad=0.25 pd=1.5 as=0.25 ps=1.5 w=1 l=1
X1 VGND VGND.t15 VGND VGND.t4 sky130_fd_pr__nfet_01v8 ad=0.25 pd=1.5 as=9 ps=54 w=1 l=1
X2 REF REF VGND VGND.t26 sky130_fd_pr__nfet_01v8 ad=0.25 pd=1.5 as=0.25 ps=1.5 w=1 l=1
X3 VGND REF REF VGND.t29 sky130_fd_pr__nfet_01v8 ad=0.25 pd=1.5 as=0.25 ps=1.5 w=1 l=1
X4 OUT REF VGND VGND.t22 sky130_fd_pr__nfet_01v8 ad=0.25 pd=1.5 as=0.25 ps=1.5 w=1 l=1
X5 VGND REF REF VGND.t27 sky130_fd_pr__nfet_01v8 ad=0.25 pd=1.5 as=0.25 ps=1.5 w=1 l=1
X6 VGND VGND.t6 VGND.t8 VGND.t7 sky130_fd_pr__nfet_01v8 ad=0.25 pd=1.5 as=0 ps=0 w=1 l=1
X7 OUT REF VGND VGND.t24 sky130_fd_pr__nfet_01v8 ad=0.25 pd=1.5 as=0.25 ps=1.5 w=1 l=1
X8 VGND.t11 VGND.t9 VGND VGND.t10 sky130_fd_pr__nfet_01v8 ad=0.25 pd=1.5 as=0 ps=0 w=1 l=1
X9 VGND REF OUT VGND.t23 sky130_fd_pr__nfet_01v8 ad=0.25 pd=1.5 as=0.25 ps=1.5 w=1 l=1
X10 VGND REF OUT VGND.t30 sky130_fd_pr__nfet_01v8 ad=0.25 pd=1.5 as=0.25 ps=1.5 w=1 l=1
X11 REF REF VGND VGND.t28 sky130_fd_pr__nfet_01v8 ad=0.25 pd=1.5 as=0.25 ps=1.5 w=1 l=1
X12 REF REF VGND VGND.t26 sky130_fd_pr__nfet_01v8 ad=0.25 pd=1.5 as=0.25 ps=1.5 w=1 l=1
X13 VGND REF REF VGND.t29 sky130_fd_pr__nfet_01v8 ad=0.25 pd=1.5 as=0.25 ps=1.5 w=1 l=1
X14 VGND REF REF VGND.t27 sky130_fd_pr__nfet_01v8 ad=0.25 pd=1.5 as=0.25 ps=1.5 w=1 l=1
X15 VGND VGND.t17 VGND VGND.t7 sky130_fd_pr__nfet_01v8 ad=0.25 pd=1.5 as=0 ps=0 w=1 l=1
X16 VGND.t2 VGND.t0 VGND VGND.t1 sky130_fd_pr__nfet_01v8 ad=0.5 pd=3 as=0 ps=0 w=1 l=1
X17 OUT REF VGND VGND.t24 sky130_fd_pr__nfet_01v8 ad=0.25 pd=1.5 as=0.25 ps=1.5 w=1 l=1
X18 VGND.t21 VGND.t19 VGND VGND.t10 sky130_fd_pr__nfet_01v8 ad=0.25 pd=1.5 as=0 ps=0 w=1 l=1
X19 VGND VGND.t3 VGND.t5 VGND.t4 sky130_fd_pr__nfet_01v8 ad=0.25 pd=1.5 as=0 ps=0 w=1 l=1
X20 VGND REF OUT VGND.t30 sky130_fd_pr__nfet_01v8 ad=0.25 pd=1.5 as=0.25 ps=1.5 w=1 l=1
X21 OUT REF VGND VGND.t22 sky130_fd_pr__nfet_01v8 ad=0.25 pd=1.5 as=0.25 ps=1.5 w=1 l=1
X22 VGND.t14 VGND.t12 VGND VGND.t1 sky130_fd_pr__nfet_01v8 ad=0.5 pd=3 as=0 ps=0 w=1 l=1
X23 VGND REF OUT VGND.t23 sky130_fd_pr__nfet_01v8 ad=0.25 pd=1.5 as=0.25 ps=1.5 w=1 l=1
C0 OUT REF 1.63826f
R0 VGND.n211 VGND.n210 585
R1 VGND.n237 VGND.n236 585
R2 VGND.n234 VGND.n212 585
R3 VGND.n232 VGND.n231 585
R4 VGND.n214 VGND.n213 585
R5 VGND.n230 VGND.n229 585
R6 VGND.n227 VGND.n215 585
R7 VGND.n225 VGND.n224 585
R8 VGND.n217 VGND.n216 585
R9 VGND.n223 VGND.n222 585
R10 VGND.n220 VGND.n218 585
R11 VGND.n208 VGND.n207 585
R12 VGND.n240 VGND.n239 585
R13 VGND.n239 VGND.n238 585
R14 VGND.n204 VGND.n203 585
R15 VGND.n203 VGND.n202 585
R16 VGND.n246 VGND.n245 585
R17 VGND.n247 VGND.n246 585
R18 VGND.n200 VGND.n199 585
R19 VGND.n201 VGND.n200 585
R20 VGND.n251 VGND.n250 585
R21 VGND.n250 VGND.n249 585
R22 VGND.n194 VGND.n193 585
R23 VGND.n193 VGND.n192 585
R24 VGND.n257 VGND.n256 585
R25 VGND.n258 VGND.n257 585
R26 VGND.n190 VGND.n189 585
R27 VGND.n191 VGND.n190 585
R28 VGND.n261 VGND.n260 585
R29 VGND.n260 VGND.n259 585
R30 VGND.n184 VGND.n183 585
R31 VGND.n183 VGND.n182 585
R32 VGND.n267 VGND.n266 585
R33 VGND.n268 VGND.n267 585
R34 VGND.n180 VGND.n179 585
R35 VGND.n181 VGND.n180 585
R36 VGND.n271 VGND.n270 585
R37 VGND.n270 VGND.n269 585
R38 VGND.n174 VGND.n173 585
R39 VGND.n173 VGND.n172 585
R40 VGND.n277 VGND.n276 585
R41 VGND.n278 VGND.n277 585
R42 VGND.n170 VGND.n169 585
R43 VGND.n171 VGND.n170 585
R44 VGND.n281 VGND.n280 585
R45 VGND.n280 VGND.n279 585
R46 VGND.n164 VGND.n163 585
R47 VGND.n163 VGND.n162 585
R48 VGND.n287 VGND.n286 585
R49 VGND.n288 VGND.n287 585
R50 VGND.n160 VGND.n159 585
R51 VGND.n161 VGND.n160 585
R52 VGND.n291 VGND.n290 585
R53 VGND.n290 VGND.n289 585
R54 VGND.n154 VGND.n153 585
R55 VGND.n153 VGND.n152 585
R56 VGND.n297 VGND.n296 585
R57 VGND.n298 VGND.n297 585
R58 VGND.n150 VGND.n149 585
R59 VGND.n151 VGND.n150 585
R60 VGND.n301 VGND.n300 585
R61 VGND.n300 VGND.n299 585
R62 VGND.t28 VGND.n144 585
R63 VGND.n144 VGND.n143 585
R64 VGND.n307 VGND.n306 585
R65 VGND.n308 VGND.n307 585
R66 VGND.n141 VGND.n140 585
R67 VGND.n142 VGND.n141 585
R68 VGND.n312 VGND.n310 585
R69 VGND.n310 VGND.n309 585
R70 VGND.n311 VGND.n135 585
R71 VGND.n135 VGND.n134 585
R72 VGND.n318 VGND.n317 585
R73 VGND.n319 VGND.n318 585
R74 VGND.n132 VGND.n131 585
R75 VGND.n133 VGND.n132 585
R76 VGND.n323 VGND.n321 585
R77 VGND.n321 VGND.n320 585
R78 VGND.n322 VGND.n126 585
R79 VGND.n126 VGND.n125 585
R80 VGND.n329 VGND.n328 585
R81 VGND.n330 VGND.n329 585
R82 VGND.n123 VGND.n122 585
R83 VGND.n124 VGND.n123 585
R84 VGND.n334 VGND.n332 585
R85 VGND.n332 VGND.n331 585
R86 VGND.n333 VGND.n117 585
R87 VGND.n117 VGND.n116 585
R88 VGND.n340 VGND.n339 585
R89 VGND.n341 VGND.n340 585
R90 VGND.n114 VGND.n113 585
R91 VGND.n115 VGND.n114 585
R92 VGND.n345 VGND.n343 585
R93 VGND.n343 VGND.n342 585
R94 VGND.n344 VGND.n108 585
R95 VGND.n108 VGND.n107 585
R96 VGND.n351 VGND.n350 585
R97 VGND.n352 VGND.n351 585
R98 VGND.n105 VGND.n104 585
R99 VGND.n106 VGND.n105 585
R100 VGND.n356 VGND.n354 585
R101 VGND.n354 VGND.n353 585
R102 VGND.n355 VGND.n99 585
R103 VGND.n99 VGND.n98 585
R104 VGND.n362 VGND.n361 585
R105 VGND.n363 VGND.n362 585
R106 VGND.n96 VGND.n95 585
R107 VGND.n97 VGND.n96 585
R108 VGND.n366 VGND.n365 585
R109 VGND.n365 VGND.n364 585
R110 VGND.n87 VGND.n86 585
R111 VGND.n86 VGND.n85 585
R112 VGND.n372 VGND.t1 585
R113 VGND.n373 VGND.n372 585
R114 VGND.n88 VGND.n84 585
R115 VGND.n40 VGND.n84 585
R116 VGND.n376 VGND.n83 585
R117 VGND.n376 VGND.n375 585
R118 VGND.n378 VGND.n377 585
R119 VGND.n377 VGND.n69 585
R120 VGND.n72 VGND.n70 585
R121 VGND.n403 VGND.n70 585
R122 VGND.n380 VGND.n80 585
R123 VGND.n384 VGND.n383 585
R124 VGND.n386 VGND.n385 585
R125 VGND.n389 VGND.n388 585
R126 VGND.n387 VGND.n79 585
R127 VGND.n391 VGND.n390 585
R128 VGND.n393 VGND.n392 585
R129 VGND.n395 VGND.n394 585
R130 VGND.n78 VGND.n77 585
R131 VGND.n397 VGND.n396 585
R132 VGND.n71 VGND.n2 585
R133 VGND.n402 VGND.n401 585
R134 VGND.n381 VGND.n72 585
R135 VGND.n382 VGND.n381 585
R136 VGND.n379 VGND.n378 585
R137 VGND.n379 VGND.n81 585
R138 VGND.n83 VGND.n82 585
R139 VGND.n369 VGND.n82 585
R140 VGND.n90 VGND.n88 585
R141 VGND.n92 VGND.n90 585
R142 VGND.t1 VGND.n371 585
R143 VGND.n371 VGND.n370 585
R144 VGND.n89 VGND.n87 585
R145 VGND.n91 VGND.n89 585
R146 VGND.n367 VGND.n366 585
R147 VGND.n368 VGND.n367 585
R148 VGND.n95 VGND.n94 585
R149 VGND.n94 VGND.n93 585
R150 VGND.n361 VGND.n360 585
R151 VGND.n360 VGND.n359 585
R152 VGND.n355 VGND.n100 585
R153 VGND.n101 VGND.n100 585
R154 VGND.n357 VGND.n356 585
R155 VGND.n358 VGND.n357 585
R156 VGND.n104 VGND.n103 585
R157 VGND.n103 VGND.n102 585
R158 VGND.n350 VGND.n349 585
R159 VGND.n349 VGND.n348 585
R160 VGND.n344 VGND.n109 585
R161 VGND.n110 VGND.n109 585
R162 VGND.n346 VGND.n345 585
R163 VGND.n347 VGND.n346 585
R164 VGND.n113 VGND.n112 585
R165 VGND.n112 VGND.n111 585
R166 VGND.n339 VGND.n338 585
R167 VGND.n338 VGND.n337 585
R168 VGND.n333 VGND.n118 585
R169 VGND.n119 VGND.n118 585
R170 VGND.n335 VGND.n334 585
R171 VGND.n336 VGND.n335 585
R172 VGND.n122 VGND.n121 585
R173 VGND.n121 VGND.n120 585
R174 VGND.n328 VGND.n327 585
R175 VGND.n327 VGND.n326 585
R176 VGND.n322 VGND.n127 585
R177 VGND.n128 VGND.n127 585
R178 VGND.n324 VGND.n323 585
R179 VGND.n325 VGND.n324 585
R180 VGND.n131 VGND.n130 585
R181 VGND.n130 VGND.n129 585
R182 VGND.n317 VGND.n316 585
R183 VGND.n316 VGND.n315 585
R184 VGND.n311 VGND.n136 585
R185 VGND.n137 VGND.n136 585
R186 VGND.n313 VGND.n312 585
R187 VGND.n314 VGND.n313 585
R188 VGND.n140 VGND.n139 585
R189 VGND.n139 VGND.n138 585
R190 VGND.n306 VGND.n305 585
R191 VGND.n305 VGND.n304 585
R192 VGND.n145 VGND.t28 585
R193 VGND.n146 VGND.n145 585
R194 VGND.n302 VGND.n301 585
R195 VGND.n303 VGND.n302 585
R196 VGND.n149 VGND.n148 585
R197 VGND.n148 VGND.n147 585
R198 VGND.n296 VGND.n295 585
R199 VGND.n295 VGND.n294 585
R200 VGND.n155 VGND.n154 585
R201 VGND.n156 VGND.n155 585
R202 VGND.n292 VGND.n291 585
R203 VGND.n293 VGND.n292 585
R204 VGND.n159 VGND.n158 585
R205 VGND.n158 VGND.n157 585
R206 VGND.n286 VGND.n285 585
R207 VGND.n285 VGND.n284 585
R208 VGND.n165 VGND.n164 585
R209 VGND.n166 VGND.n165 585
R210 VGND.n282 VGND.n281 585
R211 VGND.n283 VGND.n282 585
R212 VGND.n169 VGND.n168 585
R213 VGND.n168 VGND.n167 585
R214 VGND.n276 VGND.n275 585
R215 VGND.n275 VGND.n274 585
R216 VGND.n175 VGND.n174 585
R217 VGND.n176 VGND.n175 585
R218 VGND.n272 VGND.n271 585
R219 VGND.n273 VGND.n272 585
R220 VGND.n179 VGND.n178 585
R221 VGND.n178 VGND.n177 585
R222 VGND.n266 VGND.n265 585
R223 VGND.n265 VGND.n264 585
R224 VGND.n185 VGND.n184 585
R225 VGND.n186 VGND.n185 585
R226 VGND.n262 VGND.n261 585
R227 VGND.n263 VGND.n262 585
R228 VGND.n189 VGND.n188 585
R229 VGND.n188 VGND.n187 585
R230 VGND.n256 VGND.n255 585
R231 VGND.n255 VGND.n254 585
R232 VGND.n195 VGND.n194 585
R233 VGND.n196 VGND.n195 585
R234 VGND.n252 VGND.n251 585
R235 VGND.n253 VGND.n252 585
R236 VGND.n199 VGND.n198 585
R237 VGND.n198 VGND.n197 585
R238 VGND.n245 VGND.n244 585
R239 VGND.n244 VGND.n243 585
R240 VGND.n205 VGND.n204 585
R241 VGND.n206 VGND.n205 585
R242 VGND.n241 VGND.n240 585
R243 VGND.n242 VGND.n241 585
R244 VGND.n378 VGND.n72 261.387
R245 VGND.n378 VGND.n83 261.387
R246 VGND.n88 VGND.n83 261.387
R247 VGND.t1 VGND.n88 261.387
R248 VGND.t1 VGND.n87 261.387
R249 VGND.n366 VGND.n87 261.387
R250 VGND.n366 VGND.n95 261.387
R251 VGND.n361 VGND.n95 261.387
R252 VGND.n356 VGND.n355 261.387
R253 VGND.n356 VGND.n104 261.387
R254 VGND.n350 VGND.n104 261.387
R255 VGND.n345 VGND.n344 261.387
R256 VGND.n345 VGND.n113 261.387
R257 VGND.n339 VGND.n113 261.387
R258 VGND.n334 VGND.n333 261.387
R259 VGND.n334 VGND.n122 261.387
R260 VGND.n328 VGND.n122 261.387
R261 VGND.n323 VGND.n322 261.387
R262 VGND.n323 VGND.n131 261.387
R263 VGND.n317 VGND.n131 261.387
R264 VGND.n312 VGND.n311 261.387
R265 VGND.n312 VGND.n140 261.387
R266 VGND.n306 VGND.n140 261.387
R267 VGND.n306 VGND.t28 261.387
R268 VGND.n301 VGND.t28 261.387
R269 VGND.n301 VGND.n149 261.387
R270 VGND.n296 VGND.n149 261.387
R271 VGND.n296 VGND.n154 261.387
R272 VGND.n291 VGND.n159 261.387
R273 VGND.n286 VGND.n159 261.387
R274 VGND.n286 VGND.n164 261.387
R275 VGND.n281 VGND.n169 261.387
R276 VGND.n276 VGND.n169 261.387
R277 VGND.n276 VGND.n174 261.387
R278 VGND.n271 VGND.n179 261.387
R279 VGND.n266 VGND.n179 261.387
R280 VGND.n266 VGND.n184 261.387
R281 VGND.n261 VGND.n189 261.387
R282 VGND.n256 VGND.n189 261.387
R283 VGND.n256 VGND.n194 261.387
R284 VGND.n251 VGND.n199 261.387
R285 VGND.n245 VGND.n199 261.387
R286 VGND.n245 VGND.n204 261.387
R287 VGND.n240 VGND.n204 261.387
R288 VGND.n235 VGND.n209 260.875
R289 VGND.n233 VGND.n209 260.875
R290 VGND.n228 VGND.n209 260.875
R291 VGND.n226 VGND.n209 260.875
R292 VGND.n221 VGND.n209 260.875
R293 VGND.n219 VGND.n209 260.875
R294 VGND.n399 VGND.n73 260.875
R295 VGND.n399 VGND.n74 260.875
R296 VGND.n399 VGND.n75 260.875
R297 VGND.n399 VGND.n76 260.875
R298 VGND.n399 VGND.n398 260.875
R299 VGND.n400 VGND.n399 260.875
R300 VGND.n355 VGND.t4 217.822
R301 VGND.n317 VGND.t27 217.822
R302 VGND.n291 VGND.t29 217.822
R303 VGND.t10 VGND.n194 217.822
R304 VGND.n241 VGND.n208 197
R305 VGND.n239 VGND.n210 197
R306 VGND.n401 VGND.n70 197
R307 VGND.n381 VGND.n380 197
R308 VGND.t19 VGND.n41 60.5793
R309 VGND.t12 VGND.t15 60.5437
R310 VGND.t0 VGND.t3 60.5506
R311 VGND.n344 VGND.t22 174.257
R312 VGND.n328 VGND.t26 174.257
R313 VGND.n281 VGND.t24 174.257
R314 VGND.t7 VGND.n184 174.257
R315 VGND.n381 VGND.n379 141.84
R316 VGND.n379 VGND.n82 141.84
R317 VGND.n90 VGND.n82 141.84
R318 VGND.n371 VGND.n90 141.84
R319 VGND.n371 VGND.n89 141.84
R320 VGND.n367 VGND.n89 141.84
R321 VGND.n367 VGND.n94 141.84
R322 VGND.n360 VGND.n94 141.84
R323 VGND.n360 VGND.n100 141.84
R324 VGND.n357 VGND.n100 141.84
R325 VGND.n357 VGND.n103 141.84
R326 VGND.n349 VGND.n103 141.84
R327 VGND.n349 VGND.n109 141.84
R328 VGND.n346 VGND.n109 141.84
R329 VGND.n346 VGND.n112 141.84
R330 VGND.n338 VGND.n112 141.84
R331 VGND.n338 VGND.n118 141.84
R332 VGND.n335 VGND.n118 141.84
R333 VGND.n335 VGND.n121 141.84
R334 VGND.n327 VGND.n121 141.84
R335 VGND.n327 VGND.n127 141.84
R336 VGND.n324 VGND.n127 141.84
R337 VGND.n324 VGND.n130 141.84
R338 VGND.n316 VGND.n130 141.84
R339 VGND.n316 VGND.n136 141.84
R340 VGND.n313 VGND.n136 141.84
R341 VGND.n313 VGND.n139 141.84
R342 VGND.n305 VGND.n139 141.84
R343 VGND.n305 VGND.n145 141.84
R344 VGND.n302 VGND.n145 141.84
R345 VGND.n302 VGND.n148 141.84
R346 VGND.n295 VGND.n148 141.84
R347 VGND.n295 VGND.n155 141.84
R348 VGND.n292 VGND.n155 141.84
R349 VGND.n292 VGND.n158 141.84
R350 VGND.n285 VGND.n158 141.84
R351 VGND.n285 VGND.n165 141.84
R352 VGND.n282 VGND.n165 141.84
R353 VGND.n282 VGND.n168 141.84
R354 VGND.n275 VGND.n168 141.84
R355 VGND.n275 VGND.n175 141.84
R356 VGND.n272 VGND.n175 141.84
R357 VGND.n272 VGND.n178 141.84
R358 VGND.n265 VGND.n178 141.84
R359 VGND.n265 VGND.n185 141.84
R360 VGND.n262 VGND.n185 141.84
R361 VGND.n262 VGND.n188 141.84
R362 VGND.n255 VGND.n188 141.84
R363 VGND.n255 VGND.n195 141.84
R364 VGND.n252 VGND.n195 141.84
R365 VGND.n252 VGND.n198 141.84
R366 VGND.n244 VGND.n198 141.84
R367 VGND.n244 VGND.n205 141.84
R368 VGND.n241 VGND.n205 141.84
R369 VGND.n236 VGND.n234 141.84
R370 VGND.n232 VGND.n213 141.84
R371 VGND.n229 VGND.n227 141.84
R372 VGND.n225 VGND.n216 141.84
R373 VGND.n222 VGND.n220 141.84
R374 VGND.n377 VGND.n70 141.84
R375 VGND.n377 VGND.n376 141.84
R376 VGND.n376 VGND.n84 141.84
R377 VGND.n372 VGND.n84 141.84
R378 VGND.n372 VGND.n86 141.84
R379 VGND.n365 VGND.n86 141.84
R380 VGND.n365 VGND.n96 141.84
R381 VGND.n362 VGND.n96 141.84
R382 VGND.n362 VGND.n99 141.84
R383 VGND.n354 VGND.n99 141.84
R384 VGND.n354 VGND.n105 141.84
R385 VGND.n351 VGND.n105 141.84
R386 VGND.n351 VGND.n108 141.84
R387 VGND.n343 VGND.n108 141.84
R388 VGND.n343 VGND.n114 141.84
R389 VGND.n340 VGND.n114 141.84
R390 VGND.n340 VGND.n117 141.84
R391 VGND.n332 VGND.n117 141.84
R392 VGND.n332 VGND.n123 141.84
R393 VGND.n329 VGND.n123 141.84
R394 VGND.n329 VGND.n126 141.84
R395 VGND.n321 VGND.n126 141.84
R396 VGND.n321 VGND.n132 141.84
R397 VGND.n318 VGND.n132 141.84
R398 VGND.n318 VGND.n135 141.84
R399 VGND.n310 VGND.n135 141.84
R400 VGND.n310 VGND.n141 141.84
R401 VGND.n307 VGND.n141 141.84
R402 VGND.n307 VGND.n144 141.84
R403 VGND.n300 VGND.n144 141.84
R404 VGND.n300 VGND.n150 141.84
R405 VGND.n297 VGND.n150 141.84
R406 VGND.n297 VGND.n153 141.84
R407 VGND.n290 VGND.n153 141.84
R408 VGND.n290 VGND.n160 141.84
R409 VGND.n287 VGND.n160 141.84
R410 VGND.n287 VGND.n163 141.84
R411 VGND.n280 VGND.n163 141.84
R412 VGND.n280 VGND.n170 141.84
R413 VGND.n277 VGND.n170 141.84
R414 VGND.n277 VGND.n173 141.84
R415 VGND.n270 VGND.n173 141.84
R416 VGND.n270 VGND.n180 141.84
R417 VGND.n267 VGND.n180 141.84
R418 VGND.n267 VGND.n183 141.84
R419 VGND.n260 VGND.n183 141.84
R420 VGND.n260 VGND.n190 141.84
R421 VGND.n257 VGND.n190 141.84
R422 VGND.n257 VGND.n193 141.84
R423 VGND.n250 VGND.n193 141.84
R424 VGND.n250 VGND.n200 141.84
R425 VGND.n246 VGND.n200 141.84
R426 VGND.n246 VGND.n203 141.84
R427 VGND.n239 VGND.n203 141.84
R428 VGND.n397 VGND.n71 141.84
R429 VGND.n394 VGND.n77 141.84
R430 VGND.n392 VGND.n391 141.84
R431 VGND.n388 VGND.n387 141.84
R432 VGND.n385 VGND.n384 141.84
R433 VGND.n339 VGND.t23 130.694
R434 VGND.n333 VGND.t23 130.694
R435 VGND.t30 VGND.n174 130.694
R436 VGND.n271 VGND.t30 130.694
R437 VGND.n350 VGND.t22 87.1292
R438 VGND.n322 VGND.t26 87.1292
R439 VGND.t24 VGND.n164 87.1292
R440 VGND.n261 VGND.t7 87.1292
R441 VGND.n236 VGND.n235 63.2529
R442 VGND.n233 VGND.n232 63.2529
R443 VGND.n229 VGND.n228 63.2529
R444 VGND.n226 VGND.n225 63.2529
R445 VGND.n222 VGND.n221 63.2529
R446 VGND.n220 VGND.n219 63.2529
R447 VGND.n380 VGND.n73 63.2529
R448 VGND.n385 VGND.n74 63.2529
R449 VGND.n387 VGND.n75 63.2529
R450 VGND.n392 VGND.n76 63.2529
R451 VGND.n398 VGND.n77 63.2529
R452 VGND.n400 VGND.n71 63.2529
R453 VGND.n235 VGND.n210 63.2529
R454 VGND.n234 VGND.n233 63.2529
R455 VGND.n228 VGND.n213 63.2529
R456 VGND.n227 VGND.n226 63.2529
R457 VGND.n221 VGND.n216 63.2529
R458 VGND.n219 VGND.n208 63.2529
R459 VGND.n401 VGND.n400 63.2529
R460 VGND.n398 VGND.n397 63.2529
R461 VGND.n394 VGND.n76 63.2529
R462 VGND.n391 VGND.n75 63.2529
R463 VGND.n388 VGND.n74 63.2529
R464 VGND.n384 VGND.n73 63.2529
R465 VGND.n399 VGND.n72 58.0863
R466 VGND.n240 VGND.n209 58.0863
R467 VGND.n361 VGND.t4 43.5649
R468 VGND.n311 VGND.t27 43.5649
R469 VGND.t29 VGND.n154 43.5649
R470 VGND.n251 VGND.t10 43.5649
R471 VGND.n41 VGND.t17 0.112993
R472 VGND.n67 VGND.n211 3.79208
R473 VGND.n68 VGND.n402 3.79208
R474 VGND.n382 VGND.n80 12.8005
R475 VGND.n242 VGND.n207 12.8005
R476 VGND.t6 VGND.t9 60.55
R477 VGND.n238 VGND.n67 3.79208
R478 VGND.n202 VGND 9.3005
R479 VGND VGND.n65 3.11036
R480 VGND.n65 VGND.n201 3.08228
R481 VGND.n57 VGND 3.11036
R482 VGND.n192 VGND.n57 3.08228
R483 VGND VGND.n64 3.11036
R484 VGND.n64 VGND.n191 3.08228
R485 VGND.n56 VGND 3.11036
R486 VGND.n182 VGND.n56 3.08228
R487 VGND VGND.n63 3.11036
R488 VGND.n63 VGND.n181 3.08228
R489 VGND.n55 VGND 3.11036
R490 VGND.n172 VGND.n55 3.08228
R491 VGND VGND.n54 3.11036
R492 VGND.n54 VGND.n171 3.08228
R493 VGND.n53 VGND 3.11036
R494 VGND.n162 VGND.n53 3.08228
R495 VGND VGND.n62 3.11036
R496 VGND.n62 VGND.n161 3.08228
R497 VGND.n52 VGND 3.11036
R498 VGND.n152 VGND.n52 3.08228
R499 VGND VGND.n51 3.11036
R500 VGND.n51 VGND.n151 3.08228
R501 VGND.n50 VGND 3.11036
R502 VGND.n143 VGND.n50 3.08228
R503 VGND VGND.n308 9.3005
R504 VGND VGND.n61 3.11036
R505 VGND.n309 VGND.n61 3.08228
R506 VGND.n49 VGND 3.11036
R507 VGND.n49 VGND.n319 3.08228
R508 VGND VGND.n48 3.11036
R509 VGND.n320 VGND.n48 3.08228
R510 VGND.n47 VGND 3.11036
R511 VGND.n47 VGND.n330 3.08228
R512 VGND VGND.n60 3.11036
R513 VGND.n331 VGND.n60 3.08228
R514 VGND.n46 VGND 3.11036
R515 VGND.n46 VGND.n341 3.08228
R516 VGND VGND.n45 3.11036
R517 VGND.n342 VGND.n45 3.08228
R518 VGND.n44 VGND 3.11036
R519 VGND.n44 VGND.n352 3.08228
R520 VGND VGND.n59 3.11036
R521 VGND.n353 VGND.n59 3.08228
R522 VGND.n43 VGND 3.11036
R523 VGND.n43 VGND.n363 3.08228
R524 VGND VGND.n58 3.11036
R525 VGND.n364 VGND.n58 3.08228
R526 VGND.n42 VGND 3.11036
R527 VGND.n42 VGND.n373 3.08228
R528 VGND VGND.n40 9.3005
R529 VGND.n375 VGND.n66 3.08228
R530 VGND.n66 VGND 3.11036
R531 VGND.n68 VGND.n403 3.79208
R532 VGND VGND.n7 3.11036
R533 VGND.n383 VGND.n7 3.08228
R534 VGND.n6 VGND 3.11036
R535 VGND.n6 VGND.n389 3.08228
R536 VGND VGND.n5 3.11036
R537 VGND.n390 VGND.n5 3.08228
R538 VGND.n4 VGND 3.11036
R539 VGND.n4 VGND.n395 3.08228
R540 VGND VGND.n3 3.11036
R541 VGND.n396 VGND.n3 3.08228
R542 VGND VGND.n2 9.3005
R543 VGND.n68 VGND 2.75546
R544 VGND VGND.n382 9.3005
R545 VGND.n81 VGND.n8 3.08228
R546 VGND VGND.n8 3.11036
R547 VGND.n9 VGND.n92 3.08228
R548 VGND.n9 VGND 3.11036
R549 VGND.n10 VGND.n91 3.08228
R550 VGND VGND.n10 3.11036
R551 VGND.n93 VGND.n11 3.08228
R552 VGND.n11 VGND 3.11036
R553 VGND.n12 VGND.n101 3.08228
R554 VGND VGND.n12 3.11036
R555 VGND.n102 VGND.n13 3.08228
R556 VGND.n13 VGND 3.11036
R557 VGND.n14 VGND.n110 3.08228
R558 VGND VGND.n14 3.11036
R559 VGND.n111 VGND.n15 3.08228
R560 VGND.n15 VGND.n1 3.11036
R561 VGND.n16 VGND.n119 3.08228
R562 VGND.n1 VGND.n16 3.11036
R563 VGND.n120 VGND.n17 3.08228
R564 VGND.n17 VGND.n1 3.11036
R565 VGND.n18 VGND.n128 3.08228
R566 VGND.n1 VGND.n18 3.11036
R567 VGND.n129 VGND.n19 3.08228
R568 VGND.n19 VGND.n1 3.11036
R569 VGND.n20 VGND.n137 3.08228
R570 VGND.n1 VGND.n20 3.11036
R571 VGND.n138 VGND.n21 3.08228
R572 VGND.n21 VGND.n1 3.11036
R573 VGND.n22 VGND.n146 3.08228
R574 VGND.n1 VGND.n22 3.11036
R575 VGND.n147 VGND.n23 3.08228
R576 VGND.n23 VGND.n0 3.11036
R577 VGND.n24 VGND.n156 3.08228
R578 VGND.n0 VGND.n24 3.11036
R579 VGND.n157 VGND.n25 3.08228
R580 VGND.n25 VGND.n0 3.11036
R581 VGND.n26 VGND.n166 3.08228
R582 VGND.n0 VGND.n26 3.11036
R583 VGND.n167 VGND.n27 3.08228
R584 VGND.n27 VGND.n0 3.11036
R585 VGND.n28 VGND.n176 3.08228
R586 VGND.n0 VGND.n28 3.11036
R587 VGND.n177 VGND.n29 3.08228
R588 VGND.n29 VGND.n0 3.11036
R589 VGND.n30 VGND.n186 3.08228
R590 VGND.n0 VGND.n30 3.11036
R591 VGND.n187 VGND.n31 3.08228
R592 VGND.n31 VGND 3.11036
R593 VGND.n32 VGND.n196 3.08228
R594 VGND VGND.n32 3.11036
R595 VGND.n197 VGND.n33 3.08228
R596 VGND.n33 VGND 3.11036
R597 VGND.n34 VGND.n206 3.08228
R598 VGND VGND.n34 3.11036
R599 VGND VGND.n67 2.75546
R600 VGND VGND.n237 9.3005
R601 VGND.n212 VGND.n35 3.08228
R602 VGND.n35 VGND 3.11036
R603 VGND.n36 VGND.n214 3.08228
R604 VGND VGND.n36 3.11036
R605 VGND.n215 VGND.n37 3.08228
R606 VGND.n37 VGND 3.11036
R607 VGND.n38 VGND.n217 3.08228
R608 VGND VGND.n38 3.11036
R609 VGND.n218 VGND.n39 3.08228
R610 VGND.n39 VGND 3.11036
R611 VGND.n237 VGND.n211 9.2165
R612 VGND.n237 VGND.n212 9.2165
R613 VGND.n231 VGND.n35 3.08228
R614 VGND.n231 VGND.n214 9.2165
R615 VGND.n230 VGND.n36 3.08228
R616 VGND.n230 VGND.n215 9.2165
R617 VGND.n224 VGND.n37 3.08228
R618 VGND.n224 VGND.n217 9.2165
R619 VGND.n223 VGND.n38 3.08228
R620 VGND.n223 VGND.n218 9.2165
R621 VGND.n39 VGND.n207 3.08228
R622 VGND.n403 VGND.n69 9.2165
R623 VGND.n66 VGND.n69 3.08228
R624 VGND.n375 VGND.n40 9.2165
R625 VGND.n373 VGND.n40 9.2165
R626 VGND.n42 VGND.n85 3.08228
R627 VGND.n364 VGND.n85 9.2165
R628 VGND.n58 VGND.n97 3.08228
R629 VGND.n363 VGND.n97 9.2165
R630 VGND.n43 VGND.n98 3.08228
R631 VGND.n353 VGND.n98 9.2165
R632 VGND.n59 VGND.n106 3.08228
R633 VGND.n352 VGND.n106 9.2165
R634 VGND.n44 VGND.n107 3.08228
R635 VGND.n342 VGND.n107 9.2165
R636 VGND.n45 VGND.n115 3.08228
R637 VGND.n341 VGND.n115 9.2165
R638 VGND.n46 VGND.n116 3.08228
R639 VGND.n331 VGND.n116 9.2165
R640 VGND.n60 VGND.n124 3.08228
R641 VGND.n330 VGND.n124 9.2165
R642 VGND.n47 VGND.n125 3.08228
R643 VGND.n320 VGND.n125 9.2165
R644 VGND.n48 VGND.n133 3.08228
R645 VGND.n319 VGND.n133 9.2165
R646 VGND.n49 VGND.n134 3.08228
R647 VGND.n309 VGND.n134 9.2165
R648 VGND.n61 VGND.n142 3.08228
R649 VGND.n308 VGND.n142 9.2165
R650 VGND.n308 VGND.n143 9.2165
R651 VGND.n299 VGND.n50 3.08228
R652 VGND.n299 VGND.n151 9.2165
R653 VGND.n298 VGND.n51 3.08228
R654 VGND.n298 VGND.n152 9.2165
R655 VGND.n289 VGND.n52 3.08228
R656 VGND.n289 VGND.n161 9.2165
R657 VGND.n288 VGND.n62 3.08228
R658 VGND.n288 VGND.n162 9.2165
R659 VGND.n279 VGND.n53 3.08228
R660 VGND.n279 VGND.n171 9.2165
R661 VGND.n278 VGND.n54 3.08228
R662 VGND.n278 VGND.n172 9.2165
R663 VGND.n269 VGND.n55 3.08228
R664 VGND.n269 VGND.n181 9.2165
R665 VGND.n268 VGND.n63 3.08228
R666 VGND.n268 VGND.n182 9.2165
R667 VGND.n259 VGND.n56 3.08228
R668 VGND.n259 VGND.n191 9.2165
R669 VGND.n258 VGND.n64 3.08228
R670 VGND.n258 VGND.n192 9.2165
R671 VGND.n249 VGND.n57 3.08228
R672 VGND.n249 VGND.n201 9.2165
R673 VGND.n247 VGND.n65 3.08228
R674 VGND.n247 VGND.n202 9.2165
R675 VGND.n238 VGND.n202 9.2165
R676 VGND.n402 VGND.n2 9.2165
R677 VGND.n396 VGND.n2 9.2165
R678 VGND.n3 VGND.n78 3.08228
R679 VGND.n395 VGND.n78 9.2165
R680 VGND.n4 VGND.n393 3.08228
R681 VGND.n393 VGND.n390 9.2165
R682 VGND.n5 VGND.n79 3.08228
R683 VGND.n389 VGND.n79 9.2165
R684 VGND.n6 VGND.n386 3.08228
R685 VGND.n386 VGND.n383 9.2165
R686 VGND.n7 VGND.n80 3.08228
R687 VGND.n382 VGND.n81 9.2165
R688 VGND.n369 VGND.n8 3.08228
R689 VGND.n369 VGND.n92 9.2165
R690 VGND.n370 VGND.n9 3.08228
R691 VGND.n370 VGND.n91 9.2165
R692 VGND.n368 VGND.n10 3.08228
R693 VGND.n368 VGND.n93 9.2165
R694 VGND.n359 VGND.n11 3.08228
R695 VGND.n359 VGND.n101 9.2165
R696 VGND.n358 VGND.n12 3.08228
R697 VGND.n358 VGND.n102 9.2165
R698 VGND.n348 VGND.n13 3.08228
R699 VGND.n348 VGND.n110 9.2165
R700 VGND.n347 VGND.n14 3.08228
R701 VGND.n347 VGND.n111 9.2165
R702 VGND.n337 VGND.n15 3.08228
R703 VGND.n337 VGND.n119 9.2165
R704 VGND.n336 VGND.n16 3.08228
R705 VGND.n336 VGND.n120 9.2165
R706 VGND.n326 VGND.n17 3.08228
R707 VGND.n326 VGND.n128 9.2165
R708 VGND.n325 VGND.n18 3.08228
R709 VGND.n325 VGND.n129 9.2165
R710 VGND.n315 VGND.n19 3.08228
R711 VGND.n315 VGND.n137 9.2165
R712 VGND.n314 VGND.n20 3.08228
R713 VGND.n314 VGND.n138 9.2165
R714 VGND.n304 VGND.n21 3.08228
R715 VGND.n304 VGND.n146 9.2165
R716 VGND.n303 VGND.n22 3.08228
R717 VGND.n303 VGND.n147 9.2165
R718 VGND.n294 VGND.n23 3.08228
R719 VGND.n294 VGND.n156 9.2165
R720 VGND.n293 VGND.n24 3.08228
R721 VGND.n293 VGND.n157 9.2165
R722 VGND.n284 VGND.n25 3.08228
R723 VGND.n284 VGND.n166 9.2165
R724 VGND.n283 VGND.n26 3.08228
R725 VGND.n283 VGND.n167 9.2165
R726 VGND.n274 VGND.n27 3.08228
R727 VGND.n274 VGND.n176 9.2165
R728 VGND.n273 VGND.n28 3.08228
R729 VGND.n273 VGND.n177 9.2165
R730 VGND.n264 VGND.n29 3.08228
R731 VGND.n264 VGND.n186 9.2165
R732 VGND.n263 VGND.n30 3.08228
R733 VGND.n263 VGND.n187 9.2165
R734 VGND.n254 VGND.n31 3.08228
R735 VGND.n254 VGND.n196 9.2165
R736 VGND.n253 VGND.n32 3.08228
R737 VGND.n253 VGND.n197 9.2165
R738 VGND.n243 VGND.n33 3.08228
R739 VGND.n243 VGND.n206 9.2165
R740 VGND.n242 VGND.n34 3.08228
R741 VGND VGND.t6 2.37042
R742 VGND VGND.t3 2.36881
R743 VGND.n374 VGND 0.685596
R744 VGND.n248 VGND 0.683192
R745 VGND VGND.n248 0.355498
R746 VGND VGND.n374 0.355498
R747 VGND.n248 VGND.n41 2.59606
R748 VGND.n374 VGND.t15 2.64535
R749 VGND VGND.n1 1.4405
R750 VGND.n1 VGND.n0 1.4405
R751 VGND.n0 VGND 1.4405
C1 OUT VGND 2.07014f
C2 REF VGND 8.59904f
