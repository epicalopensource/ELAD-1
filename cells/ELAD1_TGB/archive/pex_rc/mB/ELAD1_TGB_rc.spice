* SPICE3 file created from ELAD1_TGB.ext - technology: sky130A

X0 B ENB A VDPWR sky130_fd_pr__pfet_01v8 ad=0.6 pd=4.6 as=0.6 ps=4.6 w=2 l=0.15
X1 B EN A VGND sky130_fd_pr__nfet_01v8 ad=0.3 pd=2.6 as=0.3 ps=2.6 w=1 l=0.15
C0 A ENB 0.12344f
C1 B A 0.79815f
C2 ENB VDPWR 0.32922f
C3 B VDPWR 0.2f
C4 EN ENB 0
C5 B EN 0.11626f
C6 A VDPWR 0.23723f
C7 A EN 0.06693f
C8 EN VDPWR 0
C9 B ENB 0.08431f
C10 B VGND 0.4968f **FLOATING
C11 A VGND 0.46362f **FLOATING
C12 VDPWR VGND 1.97439f **FLOATING
C13 EN VGND 0.35751f **FLOATING
C14 ENB VGND 0.05387f **FLOATING
