* tgb leak postRC tt
.lib /foss/pdks/sky130A/libs.tech/ngspice/sky130.lib.spice tt
.include /foss/designs/ELAD-1/cells/ELAD1_TGB/pex_rc/ELAD1_TGB_rc_sub.spice
XDUT A B EN ENB VDPWR VGND  ELAD1_TGB
VDD VDPWR 0 1.8
VG0 VGND 0 0
.option rshunt=1e12
.temp -20
VEN EN 0 0
VENB ENB 0 1.8
VA A 0 1.8
VB B 0 0
.control
set filetype=ascii
dc VA 1.8 1.8 1
wrdata results_dc/postRC/sweeps/leak_tt_-20.txt i(VB)
quit
.endc
.end
