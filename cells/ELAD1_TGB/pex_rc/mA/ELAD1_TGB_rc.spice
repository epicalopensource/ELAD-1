* SPICE3 file created from ELAD1_TGB_flat.ext - technology: sky130A

X0 B.t1 ENB A.t1 VDPWR sky130_fd_pr__pfet_01v8 ad=0.6 pd=4.6 as=0.6 ps=4.6 w=2 l=0.15
X1 B.t0 EN A.t0 VGND sky130_fd_pr__nfet_01v8 ad=0.3 pd=2.6 as=0.3 ps=2.6 w=1 l=0.15
C0 ENB EN 0
C1 A VDPWR 0.23723f
C2 VDPWR B 0.2f
C3 A B 0.79815f
C4 VDPWR ENB 0.32922f
C5 A ENB 0.12344f
C6 ENB B 0.08431f
C7 VDPWR EN 0
C8 A EN 0.06693f
C9 B EN 0.11626f
R0 B.n14 B.n13 585
R1 B.n13 B.n12 285.877
R2 B.n13 B.n3 285.877
R3 B.n17 B.t0 136.311
R4 B.n14 B.n2 27.1064
R5 B.n11 B.n4 27.1064
R6 B.n6 B.n3 22.6437
R7 B.n13 B.t1 14.7755
R8 B.n12 B.n2 13.2471
R9 B.n12 B.n11 13.2471
R10 B.n4 B.n3 13.2471
R11 B.n15 B.n14 9.35819
R12 B.n5 B.n4 9.3005
R13 B.n11 B.n10 9.3005
R14 B.n2 B.n1 9.3005
R15 B.n8 B.n7 4.5005
R16 B.n9 B.n0 4.5005
R17 B.n16 B.n15 4.5005
R18 B B.n17 3.11815
R19 B.n7 B.n6 2.40485
R20 B.n17 B.n16 1.23367
R21 B.n8 B.n5 0.154346
R22 B.n16 B.n0 0.154346
R23 B.n7 B.n0 0.154346
R24 B.n10 B.n9 0.135115
R25 B.n15 B.n1 0.115885
R26 B.n6 B.n5 0.0753802
R27 B.n9 B.n1 0.0389615
R28 B.n10 B.n8 0.0197308
R29 A.n14 A.n13 585
R30 A.n13 A.n12 285.877
R31 A.n13 A.n3 285.877
R32 A.n17 A.t0 136.504
R33 A.n14 A.n2 27.1064
R34 A.n11 A.n4 27.1064
R35 A.n6 A.n3 22.6437
R36 A.n13 A.t1 14.7755
R37 A.n12 A.n2 13.2471
R38 A.n12 A.n11 13.2471
R39 A.n4 A.n3 13.2471
R40 A.n15 A.n14 9.35819
R41 A.n5 A.n4 9.3005
R42 A.n11 A.n10 9.3005
R43 A.n2 A.n1 9.3005
R44 A.n8 A.n7 4.5005
R45 A.n9 A.n0 4.5005
R46 A.n16 A.n15 4.5005
R47 A A.n17 2.71444
R48 A.n7 A.n6 2.40485
R49 A.n17 A.n16 1.04137
R50 A.n8 A.n5 0.154346
R51 A.n16 A.n0 0.154346
R52 A.n7 A.n0 0.154346
R53 A.n10 A.n9 0.135115
R54 A.n15 A.n1 0.115885
R55 A.n6 A.n5 0.0753802
R56 A.n9 A.n1 0.0389615
R57 A.n10 A.n8 0.0197308
C10 EN VGND 0.35751f **FLOATING
C11 B VGND 0.65252f **FLOATING
C12 A VGND 0.63224f **FLOATING
C13 ENB VGND 0.05387f **FLOATING
C14 VDPWR VGND 1.9744f **FLOATING
C15 A.t0 VGND 0.06844f **FLOATING
C16 A.n0 VGND 0.02283f **FLOATING
C17 A.n1 VGND 0.01142f **FLOATING
C18 A.n2 VGND 0.0168f **FLOATING
C19 A.t1 VGND 0.04117f **FLOATING
C20 A.n3 VGND 0.00678f **FLOATING
C21 A.n4 VGND 0.0168f **FLOATING
C22 A.n5 VGND 0.02283f **FLOATING
C23 A.n6 VGND 0.03968f **FLOATING
C24 A.n7 VGND 0.0681f **FLOATING
C25 A.n8 VGND 0.01284f **FLOATING
C26 A.n9 VGND 0.01284f **FLOATING
C27 A.n10 VGND 0.01142f **FLOATING
C28 A.n11 VGND 0.0168f **FLOATING
C29 A.n13 VGND 0.1235f **FLOATING
C30 A.n14 VGND 0.01618f **FLOATING
C31 A.n15 VGND 0.02693f **FLOATING
C32 A.n16 VGND 0.08866f **FLOATING
C33 A.n17 VGND 0.43313f **FLOATING
C34 B.t0 VGND 0.06656f **FLOATING
C35 B.n0 VGND 0.02233f **FLOATING
C36 B.n1 VGND 0.01116f **FLOATING
C37 B.n2 VGND 0.01642f **FLOATING
C38 B.n3 VGND 0.00663f **FLOATING
C39 B.t1 VGND 0.04026f **FLOATING
C40 B.n4 VGND 0.01642f **FLOATING
C41 B.n5 VGND 0.02233f **FLOATING
C42 B.n6 VGND 0.0388f **FLOATING
C43 B.n7 VGND 0.0666f **FLOATING
C44 B.n8 VGND 0.01256f **FLOATING
C45 B.n9 VGND 0.01256f **FLOATING
C46 B.n10 VGND 0.01116f **FLOATING
C47 B.n11 VGND 0.01642f **FLOATING
C48 B.n13 VGND 0.12077f **FLOATING
C49 B.n14 VGND 0.01583f **FLOATING
C50 B.n15 VGND 0.02634f **FLOATING
C51 B.n16 VGND 0.10066f **FLOATING
C52 B.n17 VGND 0.41917f **FLOATING
