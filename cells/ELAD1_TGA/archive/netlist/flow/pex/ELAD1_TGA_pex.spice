* SPICE3 file created from ELAD1_TGA_flat.ext - technology: sky130A

X0 A ENB B VDPWR sky130_fd_pr__pfet_01v8_lvt ad=0.75 pd=3.5 as=0.75 ps=3.5 w=3 l=0.35
X1 A ENB B VDPWR sky130_fd_pr__pfet_01v8_lvt ad=0.9 pd=6.6 as=0.75 ps=3.5 w=3 l=0.35
X2 A EN B VGND sky130_fd_pr__nfet_01v8_lvt ad=0.25 pd=1.5 as=0.25 ps=1.5 w=1 l=0.15
X3 B EN A VGND sky130_fd_pr__nfet_01v8_lvt ad=0.25 pd=1.5 as=0.25 ps=1.5 w=1 l=0.15
X4 B ENB A VDPWR sky130_fd_pr__pfet_01v8_lvt ad=0.75 pd=3.5 as=0.9 ps=6.6 w=3 l=0.35
X5 A EN B VGND sky130_fd_pr__nfet_01v8_lvt ad=0.25 pd=1.5 as=0.3 ps=2.6 w=1 l=0.15
X6 B ENB A VDPWR sky130_fd_pr__pfet_01v8_lvt ad=0.75 pd=3.5 as=0.75 ps=3.5 w=3 l=0.35
X7 B EN A VGND sky130_fd_pr__nfet_01v8_lvt ad=0.3 pd=2.6 as=0.25 ps=1.5 w=1 l=0.15
C0 VDPWR ENB 0.85826f
C1 EN ENB 0.00111f
C2 B A 2.63507f
C3 EN VDPWR 0.00256f
C4 A ENB 0.61358f
C5 B ENB 0.47114f
C6 VDPWR A 0.85124f
C7 EN A 0.2353f
C8 VDPWR B 0.32802f
C9 EN B 0.22293f
C10 EN VGND 0.80656f **FLOATING
C11 B VGND 0.67216f **FLOATING
C12 A VGND 1.17819f **FLOATING
C13 ENB VGND 0.11228f **FLOATING
C14 VDPWR VGND 4.15791f **FLOATING
