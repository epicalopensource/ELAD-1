* TGA ac postRC tt_-20
.lib /foss/pdks/sky130A/libs.tech/ngspice/sky130.lib.spice tt
.include /foss/designs/ELAD-1/cells/ELAD1_TGA/netlist/flow/pex_rc/ELAD1_TGA_rc_sub.spice
XDUT A B EN ENB VDPWR VGND  ELAD1_TGA
VDD VDPWR 0 1.8
VG0 VGND 0 0
.option rshunt=1e12
.temp -20
VEN EN 0 1.8
VENB ENB 0 0
VIN A 0 0.9 AC 1
CL B 0 1p
.control
set filetype=ascii
ac dec 40 1e3 1e11
let g = vdb(B)
wrdata results/postRC/sweeps/acon_tt_-20.txt g
alter VEN dc=0
alter VENB dc=1.8
ac dec 40 1e3 1e11
let g = vdb(B)
wrdata results/postRC/sweeps/acoff_tt_-20.txt g
quit
.endc
.end
