* SPICE3 file created from ELAD1_TGA_flat.ext - technology: sky130A

X0 A.t5 ENB B.t6 VDPWR sky130_fd_pr__pfet_01v8_lvt ad=0.75 pd=3.5 as=0.75 ps=3.5 w=3 l=0.35
X1 A.t7 ENB B.t5 VDPWR sky130_fd_pr__pfet_01v8_lvt ad=0.9 pd=6.6 as=0.75 ps=3.5 w=3 l=0.35
X2 A.t2 EN B.t1 VGND sky130_fd_pr__nfet_01v8_lvt ad=0.25 pd=1.5 as=0.25 ps=1.5 w=1 l=0.15
X3 B.t0 EN A.t1 VGND sky130_fd_pr__nfet_01v8_lvt ad=0.25 pd=1.5 as=0.25 ps=1.5 w=1 l=0.15
X4 B.t7 ENB A.t4 VDPWR sky130_fd_pr__pfet_01v8_lvt ad=0.75 pd=3.5 as=0.9 ps=6.6 w=3 l=0.35
X5 A.t0 EN B.t3 VGND sky130_fd_pr__nfet_01v8_lvt ad=0.25 pd=1.5 as=0.3 ps=2.6 w=1 l=0.15
X6 B.t4 ENB A.t6 VDPWR sky130_fd_pr__pfet_01v8_lvt ad=0.75 pd=3.5 as=0.75 ps=3.5 w=3 l=0.35
X7 B.t2 EN A.t3 VGND sky130_fd_pr__nfet_01v8_lvt ad=0.3 pd=2.6 as=0.25 ps=1.5 w=1 l=0.15
C0 EN VDPWR 0.00256f
C1 B A 2.63507f
C2 ENB A 0.61358f
C3 B VDPWR 0.32802f
C4 B EN 0.22293f
C5 VDPWR ENB 0.85826f
C6 EN ENB 0.00111f
C7 B ENB 0.47114f
C8 VDPWR A 0.85124f
C9 EN A 0.2353f
R0 B.n31 B.n2 285.877
R1 B.n22 B.n2 285.877
R2 B.n20 B.n2 285.877
R3 B.n10 B.n2 285.877
R4 B.n69 B.n68 285.877
R5 B.n68 B.n41 285.877
R6 B.n68 B.n42 285.877
R7 B.n68 B.n67 285.877
R8 B.n34 B.t2 136.989
R9 B.n73 B.t3 136.888
R10 B.n36 B.n35 103.132
R11 B.n35 B.t0 30.0005
R12 B.n35 B.t1 30.0005
R13 B.n30 B.n3 27.1064
R14 B.n23 B.n21 27.1064
R15 B.n19 B.n8 27.1064
R16 B.n51 B.n40 27.1064
R17 B.n55 B.n54 27.1064
R18 B.n61 B.n43 27.1064
R19 B.n11 B.n10 22.5711
R20 B.n67 B.n66 22.5711
R21 B.n32 B.n31 22.5471
R22 B.n70 B.n69 22.5471
R23 B.n2 B.t4 16.4172
R24 B.n2 B.t5 16.4172
R25 B.n68 B.t7 16.4172
R26 B.n68 B.t6 16.4172
R27 B.n22 B.n3 13.2471
R28 B.n21 B.n20 13.2471
R29 B.n10 B.n8 13.2471
R30 B.n31 B.n30 13.2471
R31 B.n23 B.n22 13.2471
R32 B.n20 B.n19 13.2471
R33 B.n69 B.n40 13.2471
R34 B.n55 B.n41 13.2471
R35 B.n61 B.n42 13.2471
R36 B.n51 B.n41 13.2471
R37 B.n54 B.n42 13.2471
R38 B.n67 B.n43 13.2471
R39 B.n30 B.n29 9.3005
R40 B.n4 B.n3 9.3005
R41 B.n24 B.n23 9.3005
R42 B.n21 B.n7 9.3005
R43 B.n19 B.n18 9.3005
R44 B.n12 B.n8 9.3005
R45 B.n44 B.n43 9.3005
R46 B.n62 B.n61 9.3005
R47 B.n54 B.n46 9.3005
R48 B.n56 B.n55 9.3005
R49 B.n52 B.n51 9.3005
R50 B.n48 B.n40 9.3005
R51 B.n66 B.n65 4.65435
R52 B.n14 B.n11 4.61815
R53 B.n33 B.n32 4.54377
R54 B.n71 B.n70 4.54377
R55 B.n1 B.n0 4.5005
R56 B.n28 B.n27 4.5005
R57 B.n26 B.n25 4.5005
R58 B.n6 B.n5 4.5005
R59 B.n17 B.n16 4.5005
R60 B.n15 B.n9 4.5005
R61 B.n14 B.n13 4.5005
R62 B.n74 B.n73 4.5005
R63 B.n72 B.n37 4.5005
R64 B.n65 B.n64 4.5005
R65 B.n63 B.n45 4.5005
R66 B.n60 B.n59 4.5005
R67 B.n58 B.n57 4.5005
R68 B.n53 B.n47 4.5005
R69 B.n50 B.n49 4.5005
R70 B.n39 B.n38 4.5005
R71 B.n36 B.n34 2.66198
R72 B.n34 B.n33 1.50816
R73 B.n72 B.n71 1.43413
R74 B B.n74 0.79565
R75 B.n37 B.n36 0.433297
R76 B.n13 B.n9 0.154346
R77 B.n74 B.n37 0.154346
R78 B.n73 B.n72 0.154346
R79 B.n71 B.n38 0.154346
R80 B.n49 B.n38 0.154346
R81 B.n49 B.n47 0.154346
R82 B.n58 B.n47 0.154346
R83 B.n59 B.n58 0.154346
R84 B.n59 B.n45 0.154346
R85 B.n65 B.n45 0.154346
R86 B.n64 B.n63 0.154346
R87 B.n12 B.n11 0.149538
R88 B.n66 B.n44 0.149538
R89 B.n18 B.n17 0.139923
R90 B.n62 B.n60 0.139923
R91 B.n7 B.n6 0.120692
R92 B.n57 B.n46 0.120692
R93 B.n33 B.n0 0.118147
R94 B.n27 B.n0 0.118147
R95 B.n27 B.n26 0.118147
R96 B.n26 B.n5 0.118147
R97 B.n16 B.n5 0.118147
R98 B.n16 B.n15 0.118147
R99 B.n15 B.n14 0.118147
R100 B.n32 B.n1 0.111077
R101 B.n70 B.n39 0.111077
R102 B.n25 B.n24 0.101462
R103 B.n56 B.n53 0.101462
R104 B.n29 B.n28 0.0918462
R105 B.n50 B.n48 0.0918462
R106 B.n28 B.n4 0.0822308
R107 B.n52 B.n50 0.0822308
R108 B.n25 B.n4 0.0726154
R109 B.n53 B.n52 0.0726154
R110 B.n29 B.n1 0.063
R111 B.n48 B.n39 0.063
R112 B.n24 B.n6 0.0533846
R113 B.n57 B.n56 0.0533846
R114 B.n17 B.n7 0.0341538
R115 B.n60 B.n46 0.0341538
R116 B.n18 B.n9 0.0149231
R117 B.n63 B.n62 0.0149231
R118 B.n13 B.n12 0.00530769
R119 B.n64 B.n44 0.00530769
R120 A.n32 A.n31 585
R121 A.n5 A.n4 585
R122 A.n22 A.n21 585
R123 A.n20 A.n10 585
R124 A.n105 A.n104 585
R125 A.n78 A.n77 585
R126 A.n95 A.n94 585
R127 A.n93 A.n83 585
R128 A.n33 A.n32 571.606
R129 A.n20 A.n19 571.606
R130 A.n106 A.n105 571.606
R131 A.n93 A.n92 571.606
R132 A.n70 A.n41 285.877
R133 A.n61 A.n41 285.877
R134 A.n59 A.n41 285.877
R135 A.n49 A.n41 285.877
R136 A.n32 A.n4 236.4
R137 A.n21 A.n20 236.4
R138 A.n105 A.n77 236.4
R139 A.n94 A.n93 236.4
R140 A.t4 A.n4 118.201
R141 A.n21 A.t4 118.201
R142 A.t7 A.n77 118.201
R143 A.n94 A.t7 118.201
R144 A.n110 A.n38 102.692
R145 A.n111 A.n37 102.692
R146 A.n38 A.t2 30.0005
R147 A.n38 A.t3 30.0005
R148 A.n37 A.t0 30.0005
R149 A.n37 A.t1 30.0005
R150 A.n69 A.n42 27.1064
R151 A.n62 A.n60 27.1064
R152 A.n58 A.n47 27.1064
R153 A.n31 A.n3 27.1064
R154 A.n31 A.n5 27.1064
R155 A.n22 A.n5 27.1064
R156 A.n22 A.n10 27.1064
R157 A.n18 A.n10 27.1064
R158 A.n104 A.n76 27.1064
R159 A.n104 A.n78 27.1064
R160 A.n95 A.n78 27.1064
R161 A.n95 A.n83 27.1064
R162 A.n91 A.n83 27.1064
R163 A.n19 A.n11 24.8567
R164 A.n92 A.n84 24.8567
R165 A.n34 A.n33 24.8327
R166 A.n107 A.n106 24.8327
R167 A.n50 A.n49 22.5711
R168 A.n71 A.n70 22.5471
R169 A.n41 A.t5 16.4172
R170 A.n41 A.t6 16.4172
R171 A.n61 A.n42 13.2471
R172 A.n60 A.n59 13.2471
R173 A.n49 A.n47 13.2471
R174 A.n70 A.n69 13.2471
R175 A.n62 A.n61 13.2471
R176 A.n59 A.n58 13.2471
R177 A.n33 A.n3 11.0627
R178 A.n19 A.n18 11.0627
R179 A.n106 A.n76 11.0627
R180 A.n92 A.n91 11.0627
R181 A.n69 A.n68 9.3005
R182 A.n43 A.n42 9.3005
R183 A.n63 A.n62 9.3005
R184 A.n60 A.n46 9.3005
R185 A.n58 A.n57 9.3005
R186 A.n51 A.n47 9.3005
R187 A.n18 A.n17 9.3005
R188 A.n12 A.n10 9.3005
R189 A.n23 A.n22 9.3005
R190 A.n24 A.n5 9.3005
R191 A.n31 A.n30 9.3005
R192 A.n7 A.n3 9.3005
R193 A.n80 A.n76 9.3005
R194 A.n104 A.n103 9.3005
R195 A.n97 A.n78 9.3005
R196 A.n96 A.n95 9.3005
R197 A.n85 A.n83 9.3005
R198 A.n91 A.n90 9.3005
R199 A.n53 A.n50 4.65435
R200 A.n15 A.n11 4.65435
R201 A.n88 A.n84 4.65435
R202 A.n113 A.n112 4.57983
R203 A.n72 A.n71 4.54377
R204 A.n35 A.n34 4.54377
R205 A.n108 A.n107 4.54377
R206 A.n40 A.n39 4.5005
R207 A.n67 A.n66 4.5005
R208 A.n65 A.n64 4.5005
R209 A.n45 A.n44 4.5005
R210 A.n56 A.n55 4.5005
R211 A.n54 A.n48 4.5005
R212 A.n53 A.n52 4.5005
R213 A.n36 A.n0 4.5005
R214 A.n16 A.n15 4.5005
R215 A.n14 A.n13 4.5005
R216 A.n9 A.n8 4.5005
R217 A.n26 A.n25 4.5005
R218 A.n27 A.n6 4.5005
R219 A.n29 A.n28 4.5005
R220 A.n2 A.n1 4.5005
R221 A.n75 A.n74 4.5005
R222 A.n102 A.n101 4.5005
R223 A.n100 A.n79 4.5005
R224 A.n99 A.n98 4.5005
R225 A.n82 A.n81 4.5005
R226 A.n87 A.n86 4.5005
R227 A.n89 A.n88 4.5005
R228 A.n110 A.n109 3.651
R229 A.n112 A.n111 3.61361
R230 A.n73 A.n72 3.28132
R231 A.n109 A.n73 3.16772
R232 A.n109 A.n108 1.10277
R233 A.n36 A.n35 1.06624
R234 A.n73 A.n0 0.873514
R235 A.n111 A.n110 0.565717
R236 A A.n113 0.355433
R237 A.n52 A.n48 0.154346
R238 A.n72 A.n39 0.154346
R239 A.n66 A.n39 0.154346
R240 A.n66 A.n65 0.154346
R241 A.n65 A.n44 0.154346
R242 A.n55 A.n44 0.154346
R243 A.n55 A.n54 0.154346
R244 A.n54 A.n53 0.154346
R245 A.n35 A.n1 0.154346
R246 A.n28 A.n1 0.154346
R247 A.n28 A.n27 0.154346
R248 A.n27 A.n26 0.154346
R249 A.n26 A.n8 0.154346
R250 A.n14 A.n8 0.154346
R251 A.n15 A.n14 0.154346
R252 A.n16 A.n13 0.154346
R253 A.n113 A.n0 0.154346
R254 A.n108 A.n74 0.154346
R255 A.n101 A.n74 0.154346
R256 A.n101 A.n100 0.154346
R257 A.n100 A.n99 0.154346
R258 A.n99 A.n81 0.154346
R259 A.n87 A.n81 0.154346
R260 A.n88 A.n87 0.154346
R261 A.n89 A.n86 0.154346
R262 A.n51 A.n50 0.149538
R263 A.n17 A.n11 0.149538
R264 A.n90 A.n84 0.149538
R265 A.n57 A.n56 0.139923
R266 A.n12 A.n9 0.139923
R267 A.n85 A.n82 0.139923
R268 A.n46 A.n45 0.120692
R269 A.n25 A.n23 0.120692
R270 A.n98 A.n96 0.120692
R271 A.n71 A.n40 0.111077
R272 A.n34 A.n2 0.111077
R273 A.n107 A.n75 0.111077
R274 A.n64 A.n63 0.101462
R275 A.n24 A.n6 0.101462
R276 A.n97 A.n79 0.101462
R277 A.n68 A.n67 0.0918462
R278 A.n29 A.n7 0.0918462
R279 A.n102 A.n80 0.0918462
R280 A.n67 A.n43 0.0822308
R281 A.n30 A.n29 0.0822308
R282 A.n103 A.n102 0.0822308
R283 A.n112 A.n36 0.0750192
R284 A.n64 A.n43 0.0726154
R285 A.n30 A.n6 0.0726154
R286 A.n103 A.n79 0.0726154
R287 A.n68 A.n40 0.063
R288 A.n7 A.n2 0.063
R289 A.n80 A.n75 0.063
R290 A.n63 A.n45 0.0533846
R291 A.n25 A.n24 0.0533846
R292 A.n98 A.n97 0.0533846
R293 A.n56 A.n46 0.0341538
R294 A.n23 A.n9 0.0341538
R295 A.n96 A.n82 0.0341538
R296 A.n57 A.n48 0.0149231
R297 A.n13 A.n12 0.0149231
R298 A.n86 A.n85 0.0149231
R299 A.n52 A.n51 0.00530769
R300 A.n17 A.n16 0.00530769
R301 A.n90 A.n89 0.00530769
C10 EN VGND 0.80656f **FLOATING
C11 B VGND 0.71484f **FLOATING
C12 A VGND 1.19699f **FLOATING
C13 ENB VGND 0.11228f **FLOATING
C14 VDPWR VGND 4.15791f **FLOATING
C15 A.n0 VGND 0.05909f **FLOATING
C16 A.n1 VGND 0.02045f **FLOATING
C17 A.n2 VGND 0.01151f **FLOATING
C18 A.n3 VGND 0.01505f **FLOATING
C19 A.n4 VGND 0.01991f **FLOATING
C20 A.n5 VGND 0.01505f **FLOATING
C21 A.n6 VGND 0.01151f **FLOATING
C22 A.n7 VGND 0.01023f **FLOATING
C23 A.n8 VGND 0.02045f **FLOATING
C24 A.n9 VGND 0.01151f **FLOATING
C25 A.n10 VGND 0.01505f **FLOATING
C26 A.n11 VGND 0.03934f **FLOATING
C27 A.n12 VGND 0.01023f **FLOATING
C28 A.n13 VGND 0.01119f **FLOATING
C29 A.n14 VGND 0.02045f **FLOATING
C30 A.n15 VGND 0.04394f **FLOATING
C31 A.n16 VGND 0.01055f **FLOATING
C32 A.n17 VGND 0.01023f **FLOATING
C33 A.n18 VGND 0.01505f **FLOATING
C34 A.n19 VGND 0.02887f **FLOATING
C35 A.n20 VGND 0.05506f **FLOATING
C36 A.t4 VGND 0.01328f **FLOATING
C37 A.n21 VGND 0.01991f **FLOATING
C38 A.n22 VGND 0.01505f **FLOATING
C39 A.n23 VGND 0.01023f **FLOATING
C40 A.n24 VGND 0.01023f **FLOATING
C41 A.n25 VGND 0.01151f **FLOATING
C42 A.n26 VGND 0.02045f **FLOATING
C43 A.n27 VGND 0.02045f **FLOATING
C44 A.n28 VGND 0.02045f **FLOATING
C45 A.n29 VGND 0.01151f **FLOATING
C46 A.n30 VGND 0.01023f **FLOATING
C47 A.n31 VGND 0.01505f **FLOATING
C48 A.n32 VGND 0.05506f **FLOATING
C49 A.n33 VGND 0.02884f **FLOATING
C50 A.n34 VGND 0.0416f **FLOATING
C51 A.n35 VGND 0.069f **FLOATING
C52 A.n36 VGND 0.06867f **FLOATING
C53 A.t1 VGND 0.03073f **FLOATING
C54 A.t0 VGND 0.03073f **FLOATING
C55 A.n37 VGND 0.07096f **FLOATING
C56 A.t3 VGND 0.03073f **FLOATING
C57 A.t2 VGND 0.03073f **FLOATING
C58 A.n38 VGND 0.07096f **FLOATING
C59 A.n39 VGND 0.02045f **FLOATING
C60 A.n40 VGND 0.01151f **FLOATING
C61 A.t6 VGND 0.09219f **FLOATING
C62 A.t5 VGND 0.09219f **FLOATING
C63 A.n41 VGND 0.18438f **FLOATING
C64 A.n42 VGND 0.01505f **FLOATING
C65 A.n43 VGND 0.01023f **FLOATING
C66 A.n44 VGND 0.02045f **FLOATING
C67 A.n45 VGND 0.01151f **FLOATING
C68 A.n46 VGND 0.01023f **FLOATING
C69 A.n47 VGND 0.01505f **FLOATING
C70 A.n48 VGND 0.01119f **FLOATING
C71 A.n49 VGND 0.00597f **FLOATING
C72 A.n50 VGND 0.03322f **FLOATING
C73 A.n51 VGND 0.01023f **FLOATING
C74 A.n52 VGND 0.01055f **FLOATING
C75 A.n53 VGND 0.04394f **FLOATING
C76 A.n54 VGND 0.02045f **FLOATING
C77 A.n55 VGND 0.02045f **FLOATING
C78 A.n56 VGND 0.01151f **FLOATING
C79 A.n57 VGND 0.01023f **FLOATING
C80 A.n58 VGND 0.01505f **FLOATING
C81 A.n60 VGND 0.01505f **FLOATING
C82 A.n62 VGND 0.01505f **FLOATING
C83 A.n63 VGND 0.01023f **FLOATING
C84 A.n64 VGND 0.01151f **FLOATING
C85 A.n65 VGND 0.02045f **FLOATING
C86 A.n66 VGND 0.02045f **FLOATING
C87 A.n67 VGND 0.01151f **FLOATING
C88 A.n68 VGND 0.01023f **FLOATING
C89 A.n69 VGND 0.01505f **FLOATING
C90 A.n70 VGND 0.00595f **FLOATING
C91 A.n71 VGND 0.03548f **FLOATING
C92 A.n72 VGND 0.13402f **FLOATING
C93 A.n73 VGND 0.20862f **FLOATING
C94 A.n74 VGND 0.02045f **FLOATING
C95 A.n75 VGND 0.01151f **FLOATING
C96 A.n76 VGND 0.01505f **FLOATING
C97 A.n77 VGND 0.01991f **FLOATING
C98 A.n78 VGND 0.01505f **FLOATING
C99 A.n79 VGND 0.01151f **FLOATING
C100 A.n80 VGND 0.01023f **FLOATING
C101 A.n81 VGND 0.02045f **FLOATING
C102 A.n82 VGND 0.01151f **FLOATING
C103 A.n83 VGND 0.01505f **FLOATING
C104 A.n84 VGND 0.03934f **FLOATING
C105 A.n85 VGND 0.01023f **FLOATING
C106 A.n86 VGND 0.01119f **FLOATING
C107 A.n87 VGND 0.02045f **FLOATING
C108 A.n88 VGND 0.04394f **FLOATING
C109 A.n89 VGND 0.01055f **FLOATING
C110 A.n90 VGND 0.01023f **FLOATING
C111 A.n91 VGND 0.01505f **FLOATING
C112 A.n92 VGND 0.02887f **FLOATING
C113 A.n93 VGND 0.05506f **FLOATING
C114 A.t7 VGND 0.01328f **FLOATING
C115 A.n94 VGND 0.01991f **FLOATING
C116 A.n95 VGND 0.01505f **FLOATING
C117 A.n96 VGND 0.01023f **FLOATING
C118 A.n97 VGND 0.01023f **FLOATING
C119 A.n98 VGND 0.01151f **FLOATING
C120 A.n99 VGND 0.02045f **FLOATING
C121 A.n100 VGND 0.02045f **FLOATING
C122 A.n101 VGND 0.02045f **FLOATING
C123 A.n102 VGND 0.01151f **FLOATING
C124 A.n103 VGND 0.01023f **FLOATING
C125 A.n104 VGND 0.01505f **FLOATING
C126 A.n105 VGND 0.05506f **FLOATING
C127 A.n106 VGND 0.02884f **FLOATING
C128 A.n107 VGND 0.0416f **FLOATING
C129 A.n108 VGND 0.07128f **FLOATING
C130 A.n109 VGND 0.23285f **FLOATING
C131 A.n110 VGND 0.39802f **FLOATING
C132 A.n111 VGND 0.39656f **FLOATING
C133 A.n112 VGND 0.13638f **FLOATING
C134 A.n113 VGND 0.03129f **FLOATING
C135 B.t2 VGND 0.06386f **FLOATING
C136 B.n0 VGND 0.0275f **FLOATING
C137 B.n1 VGND 0.01183f **FLOATING
C138 B.t5 VGND 0.09478f **FLOATING
C139 B.t4 VGND 0.09478f **FLOATING
C140 B.n2 VGND 0.18956f **FLOATING
C141 B.n3 VGND 0.01547f **FLOATING
C142 B.n4 VGND 0.01051f **FLOATING
C143 B.n5 VGND 0.0275f **FLOATING
C144 B.n6 VGND 0.01183f **FLOATING
C145 B.n7 VGND 0.01051f **FLOATING
C146 B.n8 VGND 0.01547f **FLOATING
C147 B.n9 VGND 0.0115f **FLOATING
C148 B.n10 VGND 0.00614f **FLOATING
C149 B.n11 VGND 0.03415f **FLOATING
C150 B.n12 VGND 0.01051f **FLOATING
C151 B.n13 VGND 0.01084f **FLOATING
C152 B.n14 VGND 0.05883f **FLOATING
C153 B.n15 VGND 0.0275f **FLOATING
C154 B.n16 VGND 0.0275f **FLOATING
C155 B.n17 VGND 0.01183f **FLOATING
C156 B.n18 VGND 0.01051f **FLOATING
C157 B.n19 VGND 0.01547f **FLOATING
C158 B.n21 VGND 0.01547f **FLOATING
C159 B.n23 VGND 0.01547f **FLOATING
C160 B.n24 VGND 0.01051f **FLOATING
C161 B.n25 VGND 0.01183f **FLOATING
C162 B.n26 VGND 0.0275f **FLOATING
C163 B.n27 VGND 0.0275f **FLOATING
C164 B.n28 VGND 0.01183f **FLOATING
C165 B.n29 VGND 0.01051f **FLOATING
C166 B.n30 VGND 0.01547f **FLOATING
C167 B.n31 VGND 0.00611f **FLOATING
C168 B.n32 VGND 0.03647f **FLOATING
C169 B.n33 VGND 0.10548f **FLOATING
C170 B.n34 VGND 0.41084f **FLOATING
C171 B.t1 VGND 0.03159f **FLOATING
C172 B.t0 VGND 0.03159f **FLOATING
C173 B.n35 VGND 0.07537f **FLOATING
C174 B.n36 VGND 0.4598f **FLOATING
C175 B.n37 VGND 0.03804f **FLOATING
C176 B.n38 VGND 0.02103f **FLOATING
C177 B.n39 VGND 0.01183f **FLOATING
C178 B.n40 VGND 0.01547f **FLOATING
C179 B.t6 VGND 0.09478f **FLOATING
C180 B.t7 VGND 0.09478f **FLOATING
C181 B.n43 VGND 0.01547f **FLOATING
C182 B.n44 VGND 0.01051f **FLOATING
C183 B.n45 VGND 0.02103f **FLOATING
C184 B.n46 VGND 0.01051f **FLOATING
C185 B.n47 VGND 0.02103f **FLOATING
C186 B.n48 VGND 0.01051f **FLOATING
C187 B.n49 VGND 0.02103f **FLOATING
C188 B.n50 VGND 0.01183f **FLOATING
C189 B.n51 VGND 0.01547f **FLOATING
C190 B.n52 VGND 0.01051f **FLOATING
C191 B.n53 VGND 0.01183f **FLOATING
C192 B.n54 VGND 0.01547f **FLOATING
C193 B.n55 VGND 0.01547f **FLOATING
C194 B.n56 VGND 0.01051f **FLOATING
C195 B.n57 VGND 0.01183f **FLOATING
C196 B.n58 VGND 0.02103f **FLOATING
C197 B.n59 VGND 0.02103f **FLOATING
C198 B.n60 VGND 0.01183f **FLOATING
C199 B.n61 VGND 0.01547f **FLOATING
C200 B.n62 VGND 0.01051f **FLOATING
C201 B.n63 VGND 0.0115f **FLOATING
C202 B.n64 VGND 0.01084f **FLOATING
C203 B.n65 VGND 0.04518f **FLOATING
C204 B.n66 VGND 0.03416f **FLOATING
C205 B.n67 VGND 0.00614f **FLOATING
C206 B.n68 VGND 0.18956f **FLOATING
C207 B.n69 VGND 0.00611f **FLOATING
C208 B.n70 VGND 0.03647f **FLOATING
C209 B.n71 VGND 0.09044f **FLOATING
C210 B.n72 VGND 0.09896f **FLOATING
C211 B.t3 VGND 0.06364f **FLOATING
C212 B.n73 VGND 0.2953f **FLOATING
C213 B.n74 VGND 0.0556f **FLOATING
