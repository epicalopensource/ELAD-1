* ELAD1_CONTROL: generated by gl2spice.py from ELAD1_CONTROL.nl.v (module ELAD1_CONTROL)
* 769 standard cells, 52 cell types; port order from the symbol ELAD1_CONTROL.sym
* SIMULATION netlist: diode cells rewritten (see gl2spice.py docstring); LVS uses ELAD1_CONTROL_lvs.spice

.subckt ELAD1_CONTROL clk rst_n ena ui_in[7] ui_in[6] ui_in[5] ui_in[4] ui_in[3] ui_in[2] ui_in[1] ui_in[0] en_mg en_mc en_pg en_pc en_n clr_mg clr_mc clr_pg clr_pc clr_n hen agg_clk status[7] status[6] status[5] status[4] status[3] status[2] status[1] status[0] VDPWR VGND
XFILLER_0_105 VGND VGND VDPWR VDPWR sky130_fd_sc_hd__decap_6
XFILLER_0_111 VGND VGND VDPWR VDPWR sky130_fd_sc_hd__fill_1
XFILLER_0_113 VGND VGND VDPWR VDPWR sky130_fd_sc_hd__fill_1
XFILLER_0_126 VGND VGND VDPWR VDPWR sky130_fd_sc_hd__fill_1
XFILLER_0_135 VGND VGND VDPWR VDPWR sky130_fd_sc_hd__decap_4
XFILLER_0_139 VGND VGND VDPWR VDPWR sky130_fd_sc_hd__fill_1
XFILLER_0_141 VGND VGND VDPWR VDPWR sky130_fd_sc_hd__decap_4
XFILLER_0_158 VGND VGND VDPWR VDPWR sky130_fd_sc_hd__decap_8
XFILLER_0_166 VGND VGND VDPWR VDPWR sky130_fd_sc_hd__fill_2
XFILLER_0_169 VGND VGND VDPWR VDPWR sky130_fd_sc_hd__decap_8
XFILLER_0_181 VGND VGND VDPWR VDPWR sky130_fd_sc_hd__decap_12
XFILLER_0_19 VGND VGND VDPWR VDPWR sky130_fd_sc_hd__decap_8
XFILLER_0_193 VGND VGND VDPWR VDPWR sky130_fd_sc_hd__decap_3
XFILLER_0_210 VGND VGND VDPWR VDPWR sky130_fd_sc_hd__decap_12
XFILLER_0_222 VGND VGND VDPWR VDPWR sky130_fd_sc_hd__fill_2
XFILLER_0_225 VGND VGND VDPWR VDPWR sky130_fd_sc_hd__decap_8
XFILLER_0_233 VGND VGND VDPWR VDPWR sky130_fd_sc_hd__fill_2
XFILLER_0_239 VGND VGND VDPWR VDPWR sky130_fd_sc_hd__decap_12
XFILLER_0_251 VGND VGND VDPWR VDPWR sky130_fd_sc_hd__fill_1
XFILLER_0_253 VGND VGND VDPWR VDPWR sky130_fd_sc_hd__decap_8
XFILLER_0_261 VGND VGND VDPWR VDPWR sky130_fd_sc_hd__decap_3
XFILLER_0_268 VGND VGND VDPWR VDPWR sky130_fd_sc_hd__decap_12
XFILLER_0_27 VGND VGND VDPWR VDPWR sky130_fd_sc_hd__fill_1
XFILLER_0_281 VGND VGND VDPWR VDPWR sky130_fd_sc_hd__decap_12
XFILLER_0_29 VGND VGND VDPWR VDPWR sky130_fd_sc_hd__decap_3
XFILLER_0_297 VGND VGND VDPWR VDPWR sky130_fd_sc_hd__decap_8
XFILLER_0_305 VGND VGND VDPWR VDPWR sky130_fd_sc_hd__decap_3
XFILLER_0_309 VGND VGND VDPWR VDPWR sky130_fd_sc_hd__decap_6
XFILLER_0_315 VGND VGND VDPWR VDPWR sky130_fd_sc_hd__fill_1
XFILLER_0_36 VGND VGND VDPWR VDPWR sky130_fd_sc_hd__decap_12
XFILLER_0_57 VGND VGND VDPWR VDPWR sky130_fd_sc_hd__fill_1
XFILLER_0_7 VGND VGND VDPWR VDPWR sky130_fd_sc_hd__decap_12
XFILLER_0_70 VGND VGND VDPWR VDPWR sky130_fd_sc_hd__decap_12
XFILLER_0_82 VGND VGND VDPWR VDPWR sky130_fd_sc_hd__fill_2
XFILLER_10_101 VGND VGND VDPWR VDPWR sky130_fd_sc_hd__decap_6
XFILLER_10_112 VGND VGND VDPWR VDPWR sky130_fd_sc_hd__fill_2
XFILLER_10_118 VGND VGND VDPWR VDPWR sky130_fd_sc_hd__fill_2
XFILLER_10_141 VGND VGND VDPWR VDPWR sky130_fd_sc_hd__decap_6
XFILLER_10_15 VGND VGND VDPWR VDPWR sky130_fd_sc_hd__decap_6
XFILLER_10_155 VGND VGND VDPWR VDPWR sky130_fd_sc_hd__decap_12
XFILLER_10_167 VGND VGND VDPWR VDPWR sky130_fd_sc_hd__decap_3
XFILLER_10_175 VGND VGND VDPWR VDPWR sky130_fd_sc_hd__decap_3
XFILLER_10_186 VGND VGND VDPWR VDPWR sky130_fd_sc_hd__decap_4
XFILLER_10_190 VGND VGND VDPWR VDPWR sky130_fd_sc_hd__fill_1
XFILLER_10_195 VGND VGND VDPWR VDPWR sky130_fd_sc_hd__fill_1
XFILLER_10_197 VGND VGND VDPWR VDPWR sky130_fd_sc_hd__decap_8
XFILLER_10_210 VGND VGND VDPWR VDPWR sky130_fd_sc_hd__fill_1
XFILLER_10_218 VGND VGND VDPWR VDPWR sky130_fd_sc_hd__decap_12
XFILLER_10_230 VGND VGND VDPWR VDPWR sky130_fd_sc_hd__decap_8
XFILLER_10_238 VGND VGND VDPWR VDPWR sky130_fd_sc_hd__decap_3
XFILLER_10_25 VGND VGND VDPWR VDPWR sky130_fd_sc_hd__decap_3
XFILLER_10_260 VGND VGND VDPWR VDPWR sky130_fd_sc_hd__decap_4
XFILLER_10_284 VGND VGND VDPWR VDPWR sky130_fd_sc_hd__decap_12
XFILLER_10_29 VGND VGND VDPWR VDPWR sky130_fd_sc_hd__decap_12
XFILLER_10_296 VGND VGND VDPWR VDPWR sky130_fd_sc_hd__decap_12
XFILLER_10_3 VGND VGND VDPWR VDPWR sky130_fd_sc_hd__decap_12
XFILLER_10_317 VGND VGND VDPWR VDPWR sky130_fd_sc_hd__decap_3
XFILLER_10_41 VGND VGND VDPWR VDPWR sky130_fd_sc_hd__decap_3
XFILLER_10_48 VGND VGND VDPWR VDPWR sky130_fd_sc_hd__decap_3
XFILLER_10_59 VGND VGND VDPWR VDPWR sky130_fd_sc_hd__decap_12
XFILLER_10_71 VGND VGND VDPWR VDPWR sky130_fd_sc_hd__fill_2
XFILLER_10_85 VGND VGND VDPWR VDPWR sky130_fd_sc_hd__fill_1
XFILLER_10_91 VGND VGND VDPWR VDPWR sky130_fd_sc_hd__fill_2
XFILLER_11_100 VGND VGND VDPWR VDPWR sky130_fd_sc_hd__decap_4
XFILLER_11_124 VGND VGND VDPWR VDPWR sky130_fd_sc_hd__fill_2
XFILLER_11_15 VGND VGND VDPWR VDPWR sky130_fd_sc_hd__decap_12
XFILLER_11_166 VGND VGND VDPWR VDPWR sky130_fd_sc_hd__fill_2
XFILLER_11_169 VGND VGND VDPWR VDPWR sky130_fd_sc_hd__fill_1
XFILLER_11_178 VGND VGND VDPWR VDPWR sky130_fd_sc_hd__decap_4
XFILLER_11_209 VGND VGND VDPWR VDPWR sky130_fd_sc_hd__fill_2
XFILLER_11_218 VGND VGND VDPWR VDPWR sky130_fd_sc_hd__decap_6
XFILLER_11_265 VGND VGND VDPWR VDPWR sky130_fd_sc_hd__decap_12
XFILLER_11_27 VGND VGND VDPWR VDPWR sky130_fd_sc_hd__decap_12
XFILLER_11_277 VGND VGND VDPWR VDPWR sky130_fd_sc_hd__decap_3
XFILLER_11_3 VGND VGND VDPWR VDPWR sky130_fd_sc_hd__decap_12
XFILLER_11_309 VGND VGND VDPWR VDPWR sky130_fd_sc_hd__decap_3
XFILLER_11_39 VGND VGND VDPWR VDPWR sky130_fd_sc_hd__decap_12
XFILLER_11_51 VGND VGND VDPWR VDPWR sky130_fd_sc_hd__decap_4
XFILLER_11_55 VGND VGND VDPWR VDPWR sky130_fd_sc_hd__fill_1
XFILLER_11_57 VGND VGND VDPWR VDPWR sky130_fd_sc_hd__decap_8
XFILLER_11_65 VGND VGND VDPWR VDPWR sky130_fd_sc_hd__decap_3
XFILLER_12_103 VGND VGND VDPWR VDPWR sky130_fd_sc_hd__fill_1
XFILLER_12_11 VGND VGND VDPWR VDPWR sky130_fd_sc_hd__fill_1
XFILLER_12_129 VGND VGND VDPWR VDPWR sky130_fd_sc_hd__decap_8
XFILLER_12_137 VGND VGND VDPWR VDPWR sky130_fd_sc_hd__decap_3
XFILLER_12_141 VGND VGND VDPWR VDPWR sky130_fd_sc_hd__decap_12
XFILLER_12_153 VGND VGND VDPWR VDPWR sky130_fd_sc_hd__decap_4
XFILLER_12_16 VGND VGND VDPWR VDPWR sky130_fd_sc_hd__decap_12
XFILLER_12_177 VGND VGND VDPWR VDPWR sky130_fd_sc_hd__decap_8
XFILLER_12_185 VGND VGND VDPWR VDPWR sky130_fd_sc_hd__decap_3
XFILLER_12_195 VGND VGND VDPWR VDPWR sky130_fd_sc_hd__fill_1
XFILLER_12_197 VGND VGND VDPWR VDPWR sky130_fd_sc_hd__fill_1
XFILLER_12_206 VGND VGND VDPWR VDPWR sky130_fd_sc_hd__decap_6
XFILLER_12_232 VGND VGND VDPWR VDPWR sky130_fd_sc_hd__decap_12
XFILLER_12_244 VGND VGND VDPWR VDPWR sky130_fd_sc_hd__fill_1
XFILLER_12_253 VGND VGND VDPWR VDPWR sky130_fd_sc_hd__decap_12
XFILLER_12_265 VGND VGND VDPWR VDPWR sky130_fd_sc_hd__decap_12
XFILLER_12_277 VGND VGND VDPWR VDPWR sky130_fd_sc_hd__fill_1
XFILLER_12_29 VGND VGND VDPWR VDPWR sky130_fd_sc_hd__decap_12
XFILLER_12_3 VGND VGND VDPWR VDPWR sky130_fd_sc_hd__decap_8
XFILLER_12_306 VGND VGND VDPWR VDPWR sky130_fd_sc_hd__fill_2
XFILLER_12_309 VGND VGND VDPWR VDPWR sky130_fd_sc_hd__decap_8
XFILLER_12_317 VGND VGND VDPWR VDPWR sky130_fd_sc_hd__decap_3
XFILLER_12_45 VGND VGND VDPWR VDPWR sky130_fd_sc_hd__decap_12
XFILLER_12_57 VGND VGND VDPWR VDPWR sky130_fd_sc_hd__decap_12
XFILLER_12_69 VGND VGND VDPWR VDPWR sky130_fd_sc_hd__decap_4
XFILLER_12_73 VGND VGND VDPWR VDPWR sky130_fd_sc_hd__fill_1
XFILLER_12_85 VGND VGND VDPWR VDPWR sky130_fd_sc_hd__decap_4
XFILLER_12_89 VGND VGND VDPWR VDPWR sky130_fd_sc_hd__fill_1
XFILLER_12_95 VGND VGND VDPWR VDPWR sky130_fd_sc_hd__decap_8
XFILLER_13_102 VGND VGND VDPWR VDPWR sky130_fd_sc_hd__fill_1
XFILLER_13_113 VGND VGND VDPWR VDPWR sky130_fd_sc_hd__decap_12
XFILLER_13_125 VGND VGND VDPWR VDPWR sky130_fd_sc_hd__fill_1
XFILLER_13_130 VGND VGND VDPWR VDPWR sky130_fd_sc_hd__decap_8
XFILLER_13_138 VGND VGND VDPWR VDPWR sky130_fd_sc_hd__fill_2
XFILLER_13_141 VGND VGND VDPWR VDPWR sky130_fd_sc_hd__fill_1
XFILLER_13_15 VGND VGND VDPWR VDPWR sky130_fd_sc_hd__decap_3
XFILLER_13_160 VGND VGND VDPWR VDPWR sky130_fd_sc_hd__decap_3
XFILLER_13_173 VGND VGND VDPWR VDPWR sky130_fd_sc_hd__decap_6
XFILLER_13_179 VGND VGND VDPWR VDPWR sky130_fd_sc_hd__fill_1
XFILLER_13_184 VGND VGND VDPWR VDPWR sky130_fd_sc_hd__decap_12
XFILLER_13_197 VGND VGND VDPWR VDPWR sky130_fd_sc_hd__fill_1
XFILLER_13_202 VGND VGND VDPWR VDPWR sky130_fd_sc_hd__decap_8
XFILLER_13_210 VGND VGND VDPWR VDPWR sky130_fd_sc_hd__fill_2
XFILLER_13_22 VGND VGND VDPWR VDPWR sky130_fd_sc_hd__decap_6
XFILLER_13_223 VGND VGND VDPWR VDPWR sky130_fd_sc_hd__fill_1
XFILLER_13_225 VGND VGND VDPWR VDPWR sky130_fd_sc_hd__decap_8
XFILLER_13_233 VGND VGND VDPWR VDPWR sky130_fd_sc_hd__fill_1
XFILLER_13_238 VGND VGND VDPWR VDPWR sky130_fd_sc_hd__decap_12
XFILLER_13_250 VGND VGND VDPWR VDPWR sky130_fd_sc_hd__fill_2
XFILLER_13_257 VGND VGND VDPWR VDPWR sky130_fd_sc_hd__fill_1
XFILLER_13_264 VGND VGND VDPWR VDPWR sky130_fd_sc_hd__decap_6
XFILLER_13_274 VGND VGND VDPWR VDPWR sky130_fd_sc_hd__decap_6
XFILLER_13_281 VGND VGND VDPWR VDPWR sky130_fd_sc_hd__fill_1
XFILLER_13_285 VGND VGND VDPWR VDPWR sky130_fd_sc_hd__decap_3
XFILLER_13_29 VGND VGND VDPWR VDPWR sky130_fd_sc_hd__decap_6
XFILLER_13_292 VGND VGND VDPWR VDPWR sky130_fd_sc_hd__decap_6
XFILLER_13_303 VGND VGND VDPWR VDPWR sky130_fd_sc_hd__decap_4
XFILLER_13_307 VGND VGND VDPWR VDPWR sky130_fd_sc_hd__fill_1
XFILLER_13_309 VGND VGND VDPWR VDPWR sky130_fd_sc_hd__decap_6
XFILLER_13_315 VGND VGND VDPWR VDPWR sky130_fd_sc_hd__fill_1
XFILLER_13_35 VGND VGND VDPWR VDPWR sky130_fd_sc_hd__fill_1
XFILLER_13_40 VGND VGND VDPWR VDPWR sky130_fd_sc_hd__decap_12
XFILLER_13_57 VGND VGND VDPWR VDPWR sky130_fd_sc_hd__decap_12
XFILLER_13_69 VGND VGND VDPWR VDPWR sky130_fd_sc_hd__decap_3
XFILLER_13_7 VGND VGND VDPWR VDPWR sky130_fd_sc_hd__decap_8
XFILLER_13_76 VGND VGND VDPWR VDPWR sky130_fd_sc_hd__decap_8
XFILLER_13_85 VGND VGND VDPWR VDPWR sky130_fd_sc_hd__decap_4
XFILLER_13_89 VGND VGND VDPWR VDPWR sky130_fd_sc_hd__fill_1
XFILLER_13_94 VGND VGND VDPWR VDPWR sky130_fd_sc_hd__decap_8
XFILLER_1_103 VGND VGND VDPWR VDPWR sky130_fd_sc_hd__decap_8
XFILLER_1_111 VGND VGND VDPWR VDPWR sky130_fd_sc_hd__fill_1
XFILLER_1_133 VGND VGND VDPWR VDPWR sky130_fd_sc_hd__fill_2
XFILLER_1_15 VGND VGND VDPWR VDPWR sky130_fd_sc_hd__decap_8
XFILLER_1_156 VGND VGND VDPWR VDPWR sky130_fd_sc_hd__decap_8
XFILLER_1_164 VGND VGND VDPWR VDPWR sky130_fd_sc_hd__fill_1
XFILLER_1_178 VGND VGND VDPWR VDPWR sky130_fd_sc_hd__decap_8
XFILLER_1_186 VGND VGND VDPWR VDPWR sky130_fd_sc_hd__decap_3
XFILLER_1_219 VGND VGND VDPWR VDPWR sky130_fd_sc_hd__decap_4
XFILLER_1_223 VGND VGND VDPWR VDPWR sky130_fd_sc_hd__fill_1
XFILLER_1_225 VGND VGND VDPWR VDPWR sky130_fd_sc_hd__decap_12
XFILLER_1_23 VGND VGND VDPWR VDPWR sky130_fd_sc_hd__fill_1
XFILLER_1_237 VGND VGND VDPWR VDPWR sky130_fd_sc_hd__decap_12
XFILLER_1_249 VGND VGND VDPWR VDPWR sky130_fd_sc_hd__decap_12
XFILLER_1_261 VGND VGND VDPWR VDPWR sky130_fd_sc_hd__decap_12
XFILLER_1_273 VGND VGND VDPWR VDPWR sky130_fd_sc_hd__decap_6
XFILLER_1_279 VGND VGND VDPWR VDPWR sky130_fd_sc_hd__fill_1
XFILLER_1_281 VGND VGND VDPWR VDPWR sky130_fd_sc_hd__decap_12
XFILLER_1_293 VGND VGND VDPWR VDPWR sky130_fd_sc_hd__decap_12
XFILLER_1_3 VGND VGND VDPWR VDPWR sky130_fd_sc_hd__decap_12
XFILLER_1_305 VGND VGND VDPWR VDPWR sky130_fd_sc_hd__decap_12
XFILLER_1_317 VGND VGND VDPWR VDPWR sky130_fd_sc_hd__decap_3
XFILLER_1_52 VGND VGND VDPWR VDPWR sky130_fd_sc_hd__decap_4
XFILLER_1_65 VGND VGND VDPWR VDPWR sky130_fd_sc_hd__fill_2
XFILLER_1_75 VGND VGND VDPWR VDPWR sky130_fd_sc_hd__decap_8
XFILLER_2_107 VGND VGND VDPWR VDPWR sky130_fd_sc_hd__decap_3
XFILLER_2_121 VGND VGND VDPWR VDPWR sky130_fd_sc_hd__decap_12
XFILLER_2_133 VGND VGND VDPWR VDPWR sky130_fd_sc_hd__decap_6
XFILLER_2_139 VGND VGND VDPWR VDPWR sky130_fd_sc_hd__fill_1
XFILLER_2_141 VGND VGND VDPWR VDPWR sky130_fd_sc_hd__decap_3
XFILLER_2_149 VGND VGND VDPWR VDPWR sky130_fd_sc_hd__decap_3
XFILLER_2_15 VGND VGND VDPWR VDPWR sky130_fd_sc_hd__decap_12
XFILLER_2_155 VGND VGND VDPWR VDPWR sky130_fd_sc_hd__decap_6
XFILLER_2_187 VGND VGND VDPWR VDPWR sky130_fd_sc_hd__decap_8
XFILLER_2_195 VGND VGND VDPWR VDPWR sky130_fd_sc_hd__fill_1
XFILLER_2_197 VGND VGND VDPWR VDPWR sky130_fd_sc_hd__fill_1
XFILLER_2_201 VGND VGND VDPWR VDPWR sky130_fd_sc_hd__decap_8
XFILLER_2_230 VGND VGND VDPWR VDPWR sky130_fd_sc_hd__decap_12
XFILLER_2_242 VGND VGND VDPWR VDPWR sky130_fd_sc_hd__decap_8
XFILLER_2_250 VGND VGND VDPWR VDPWR sky130_fd_sc_hd__fill_2
XFILLER_2_253 VGND VGND VDPWR VDPWR sky130_fd_sc_hd__decap_12
XFILLER_2_265 VGND VGND VDPWR VDPWR sky130_fd_sc_hd__decap_12
XFILLER_2_27 VGND VGND VDPWR VDPWR sky130_fd_sc_hd__fill_1
XFILLER_2_277 VGND VGND VDPWR VDPWR sky130_fd_sc_hd__decap_12
XFILLER_2_289 VGND VGND VDPWR VDPWR sky130_fd_sc_hd__decap_12
XFILLER_2_3 VGND VGND VDPWR VDPWR sky130_fd_sc_hd__decap_12
XFILLER_2_301 VGND VGND VDPWR VDPWR sky130_fd_sc_hd__decap_6
XFILLER_2_307 VGND VGND VDPWR VDPWR sky130_fd_sc_hd__fill_1
XFILLER_2_309 VGND VGND VDPWR VDPWR sky130_fd_sc_hd__decap_8
XFILLER_2_317 VGND VGND VDPWR VDPWR sky130_fd_sc_hd__decap_3
XFILLER_2_69 VGND VGND VDPWR VDPWR sky130_fd_sc_hd__fill_1
XFILLER_2_88 VGND VGND VDPWR VDPWR sky130_fd_sc_hd__fill_2
XFILLER_2_93 VGND VGND VDPWR VDPWR sky130_fd_sc_hd__decap_3
XFILLER_2_99 VGND VGND VDPWR VDPWR sky130_fd_sc_hd__decap_8
XFILLER_3_113 VGND VGND VDPWR VDPWR sky130_fd_sc_hd__fill_1
XFILLER_3_134 VGND VGND VDPWR VDPWR sky130_fd_sc_hd__decap_12
XFILLER_3_146 VGND VGND VDPWR VDPWR sky130_fd_sc_hd__decap_12
XFILLER_3_15 VGND VGND VDPWR VDPWR sky130_fd_sc_hd__decap_12
XFILLER_3_158 VGND VGND VDPWR VDPWR sky130_fd_sc_hd__decap_8
XFILLER_3_166 VGND VGND VDPWR VDPWR sky130_fd_sc_hd__fill_2
XFILLER_3_174 VGND VGND VDPWR VDPWR sky130_fd_sc_hd__fill_2
XFILLER_3_181 VGND VGND VDPWR VDPWR sky130_fd_sc_hd__decap_8
XFILLER_3_189 VGND VGND VDPWR VDPWR sky130_fd_sc_hd__fill_1
XFILLER_3_210 VGND VGND VDPWR VDPWR sky130_fd_sc_hd__decap_3
XFILLER_3_225 VGND VGND VDPWR VDPWR sky130_fd_sc_hd__decap_12
XFILLER_3_237 VGND VGND VDPWR VDPWR sky130_fd_sc_hd__decap_12
XFILLER_3_249 VGND VGND VDPWR VDPWR sky130_fd_sc_hd__decap_12
XFILLER_3_261 VGND VGND VDPWR VDPWR sky130_fd_sc_hd__decap_12
XFILLER_3_27 VGND VGND VDPWR VDPWR sky130_fd_sc_hd__decap_12
XFILLER_3_273 VGND VGND VDPWR VDPWR sky130_fd_sc_hd__decap_6
XFILLER_3_279 VGND VGND VDPWR VDPWR sky130_fd_sc_hd__fill_1
XFILLER_3_281 VGND VGND VDPWR VDPWR sky130_fd_sc_hd__decap_12
XFILLER_3_293 VGND VGND VDPWR VDPWR sky130_fd_sc_hd__decap_6
XFILLER_3_3 VGND VGND VDPWR VDPWR sky130_fd_sc_hd__decap_12
XFILLER_3_319 VGND VGND VDPWR VDPWR sky130_fd_sc_hd__fill_1
XFILLER_3_39 VGND VGND VDPWR VDPWR sky130_fd_sc_hd__fill_1
XFILLER_3_48 VGND VGND VDPWR VDPWR sky130_fd_sc_hd__decap_8
XFILLER_3_57 VGND VGND VDPWR VDPWR sky130_fd_sc_hd__decap_8
XFILLER_3_65 VGND VGND VDPWR VDPWR sky130_fd_sc_hd__fill_2
XFILLER_3_74 VGND VGND VDPWR VDPWR sky130_fd_sc_hd__decap_12
XFILLER_3_86 VGND VGND VDPWR VDPWR sky130_fd_sc_hd__decap_6
XFILLER_4_100 VGND VGND VDPWR VDPWR sky130_fd_sc_hd__decap_8
XFILLER_4_108 VGND VGND VDPWR VDPWR sky130_fd_sc_hd__decap_3
XFILLER_4_135 VGND VGND VDPWR VDPWR sky130_fd_sc_hd__decap_4
XFILLER_4_139 VGND VGND VDPWR VDPWR sky130_fd_sc_hd__fill_1
XFILLER_4_141 VGND VGND VDPWR VDPWR sky130_fd_sc_hd__decap_8
XFILLER_4_149 VGND VGND VDPWR VDPWR sky130_fd_sc_hd__fill_2
XFILLER_4_15 VGND VGND VDPWR VDPWR sky130_fd_sc_hd__decap_12
XFILLER_4_155 VGND VGND VDPWR VDPWR sky130_fd_sc_hd__fill_1
XFILLER_4_176 VGND VGND VDPWR VDPWR sky130_fd_sc_hd__decap_6
XFILLER_4_185 VGND VGND VDPWR VDPWR sky130_fd_sc_hd__decap_4
XFILLER_4_189 VGND VGND VDPWR VDPWR sky130_fd_sc_hd__fill_1
XFILLER_4_193 VGND VGND VDPWR VDPWR sky130_fd_sc_hd__decap_3
XFILLER_4_197 VGND VGND VDPWR VDPWR sky130_fd_sc_hd__decap_6
XFILLER_4_203 VGND VGND VDPWR VDPWR sky130_fd_sc_hd__fill_1
XFILLER_4_233 VGND VGND VDPWR VDPWR sky130_fd_sc_hd__decap_12
XFILLER_4_245 VGND VGND VDPWR VDPWR sky130_fd_sc_hd__decap_6
XFILLER_4_251 VGND VGND VDPWR VDPWR sky130_fd_sc_hd__fill_1
XFILLER_4_253 VGND VGND VDPWR VDPWR sky130_fd_sc_hd__decap_8
XFILLER_4_261 VGND VGND VDPWR VDPWR sky130_fd_sc_hd__fill_1
XFILLER_4_267 VGND VGND VDPWR VDPWR sky130_fd_sc_hd__decap_4
XFILLER_4_27 VGND VGND VDPWR VDPWR sky130_fd_sc_hd__fill_1
XFILLER_4_279 VGND VGND VDPWR VDPWR sky130_fd_sc_hd__decap_8
XFILLER_4_287 VGND VGND VDPWR VDPWR sky130_fd_sc_hd__fill_2
XFILLER_4_29 VGND VGND VDPWR VDPWR sky130_fd_sc_hd__decap_8
XFILLER_4_3 VGND VGND VDPWR VDPWR sky130_fd_sc_hd__decap_12
XFILLER_4_306 VGND VGND VDPWR VDPWR sky130_fd_sc_hd__fill_2
XFILLER_4_309 VGND VGND VDPWR VDPWR sky130_fd_sc_hd__decap_8
XFILLER_4_317 VGND VGND VDPWR VDPWR sky130_fd_sc_hd__decap_3
XFILLER_4_37 VGND VGND VDPWR VDPWR sky130_fd_sc_hd__fill_1
XFILLER_4_41 VGND VGND VDPWR VDPWR sky130_fd_sc_hd__decap_4
XFILLER_4_50 VGND VGND VDPWR VDPWR sky130_fd_sc_hd__decap_12
XFILLER_4_62 VGND VGND VDPWR VDPWR sky130_fd_sc_hd__fill_2
XFILLER_4_85 VGND VGND VDPWR VDPWR sky130_fd_sc_hd__decap_12
XFILLER_5_102 VGND VGND VDPWR VDPWR sky130_fd_sc_hd__fill_2
XFILLER_5_108 VGND VGND VDPWR VDPWR sky130_fd_sc_hd__decap_4
XFILLER_5_121 VGND VGND VDPWR VDPWR sky130_fd_sc_hd__decap_12
XFILLER_5_133 VGND VGND VDPWR VDPWR sky130_fd_sc_hd__decap_8
XFILLER_5_141 VGND VGND VDPWR VDPWR sky130_fd_sc_hd__fill_2
XFILLER_5_15 VGND VGND VDPWR VDPWR sky130_fd_sc_hd__decap_8
XFILLER_5_154 VGND VGND VDPWR VDPWR sky130_fd_sc_hd__fill_1
XFILLER_5_163 VGND VGND VDPWR VDPWR sky130_fd_sc_hd__decap_4
XFILLER_5_167 VGND VGND VDPWR VDPWR sky130_fd_sc_hd__fill_1
XFILLER_5_183 VGND VGND VDPWR VDPWR sky130_fd_sc_hd__fill_2
XFILLER_5_205 VGND VGND VDPWR VDPWR sky130_fd_sc_hd__decap_4
XFILLER_5_209 VGND VGND VDPWR VDPWR sky130_fd_sc_hd__fill_1
XFILLER_5_218 VGND VGND VDPWR VDPWR sky130_fd_sc_hd__decap_6
XFILLER_5_225 VGND VGND VDPWR VDPWR sky130_fd_sc_hd__decap_6
XFILLER_5_23 VGND VGND VDPWR VDPWR sky130_fd_sc_hd__decap_3
XFILLER_5_231 VGND VGND VDPWR VDPWR sky130_fd_sc_hd__fill_1
XFILLER_5_255 VGND VGND VDPWR VDPWR sky130_fd_sc_hd__fill_2
XFILLER_5_277 VGND VGND VDPWR VDPWR sky130_fd_sc_hd__decap_3
XFILLER_5_281 VGND VGND VDPWR VDPWR sky130_fd_sc_hd__decap_6
XFILLER_5_287 VGND VGND VDPWR VDPWR sky130_fd_sc_hd__fill_1
XFILLER_5_3 VGND VGND VDPWR VDPWR sky130_fd_sc_hd__decap_12
XFILLER_5_308 VGND VGND VDPWR VDPWR sky130_fd_sc_hd__decap_12
XFILLER_5_54 VGND VGND VDPWR VDPWR sky130_fd_sc_hd__fill_2
XFILLER_5_57 VGND VGND VDPWR VDPWR sky130_fd_sc_hd__decap_8
XFILLER_5_85 VGND VGND VDPWR VDPWR sky130_fd_sc_hd__decap_12
XFILLER_5_97 VGND VGND VDPWR VDPWR sky130_fd_sc_hd__fill_1
XFILLER_6_103 VGND VGND VDPWR VDPWR sky130_fd_sc_hd__decap_6
XFILLER_6_109 VGND VGND VDPWR VDPWR sky130_fd_sc_hd__fill_1
XFILLER_6_141 VGND VGND VDPWR VDPWR sky130_fd_sc_hd__decap_12
XFILLER_6_15 VGND VGND VDPWR VDPWR sky130_fd_sc_hd__decap_12
XFILLER_6_153 VGND VGND VDPWR VDPWR sky130_fd_sc_hd__fill_2
XFILLER_6_158 VGND VGND VDPWR VDPWR sky130_fd_sc_hd__decap_4
XFILLER_6_162 VGND VGND VDPWR VDPWR sky130_fd_sc_hd__fill_1
XFILLER_6_183 VGND VGND VDPWR VDPWR sky130_fd_sc_hd__decap_3
XFILLER_6_194 VGND VGND VDPWR VDPWR sky130_fd_sc_hd__fill_2
XFILLER_6_197 VGND VGND VDPWR VDPWR sky130_fd_sc_hd__decap_12
XFILLER_6_209 VGND VGND VDPWR VDPWR sky130_fd_sc_hd__decap_12
XFILLER_6_221 VGND VGND VDPWR VDPWR sky130_fd_sc_hd__decap_12
XFILLER_6_233 VGND VGND VDPWR VDPWR sky130_fd_sc_hd__decap_12
XFILLER_6_245 VGND VGND VDPWR VDPWR sky130_fd_sc_hd__decap_6
XFILLER_6_251 VGND VGND VDPWR VDPWR sky130_fd_sc_hd__fill_1
XFILLER_6_253 VGND VGND VDPWR VDPWR sky130_fd_sc_hd__decap_12
XFILLER_6_265 VGND VGND VDPWR VDPWR sky130_fd_sc_hd__decap_4
XFILLER_6_269 VGND VGND VDPWR VDPWR sky130_fd_sc_hd__fill_1
XFILLER_6_27 VGND VGND VDPWR VDPWR sky130_fd_sc_hd__fill_1
XFILLER_6_278 VGND VGND VDPWR VDPWR sky130_fd_sc_hd__fill_1
XFILLER_6_29 VGND VGND VDPWR VDPWR sky130_fd_sc_hd__decap_8
XFILLER_6_298 VGND VGND VDPWR VDPWR sky130_fd_sc_hd__fill_2
XFILLER_6_3 VGND VGND VDPWR VDPWR sky130_fd_sc_hd__decap_12
XFILLER_6_309 VGND VGND VDPWR VDPWR sky130_fd_sc_hd__decap_8
XFILLER_6_317 VGND VGND VDPWR VDPWR sky130_fd_sc_hd__decap_3
XFILLER_6_44 VGND VGND VDPWR VDPWR sky130_fd_sc_hd__fill_1
XFILLER_6_53 VGND VGND VDPWR VDPWR sky130_fd_sc_hd__decap_12
XFILLER_6_65 VGND VGND VDPWR VDPWR sky130_fd_sc_hd__decap_8
XFILLER_6_73 VGND VGND VDPWR VDPWR sky130_fd_sc_hd__fill_1
XFILLER_6_80 VGND VGND VDPWR VDPWR sky130_fd_sc_hd__decap_4
XFILLER_6_85 VGND VGND VDPWR VDPWR sky130_fd_sc_hd__fill_2
XFILLER_6_91 VGND VGND VDPWR VDPWR sky130_fd_sc_hd__decap_12
XFILLER_7_104 VGND VGND VDPWR VDPWR sky130_fd_sc_hd__decap_4
XFILLER_7_108 VGND VGND VDPWR VDPWR sky130_fd_sc_hd__fill_1
XFILLER_7_113 VGND VGND VDPWR VDPWR sky130_fd_sc_hd__decap_4
XFILLER_7_125 VGND VGND VDPWR VDPWR sky130_fd_sc_hd__decap_12
XFILLER_7_137 VGND VGND VDPWR VDPWR sky130_fd_sc_hd__decap_6
XFILLER_7_15 VGND VGND VDPWR VDPWR sky130_fd_sc_hd__decap_12
XFILLER_7_151 VGND VGND VDPWR VDPWR sky130_fd_sc_hd__decap_4
XFILLER_7_155 VGND VGND VDPWR VDPWR sky130_fd_sc_hd__fill_1
XFILLER_7_162 VGND VGND VDPWR VDPWR sky130_fd_sc_hd__decap_6
XFILLER_7_169 VGND VGND VDPWR VDPWR sky130_fd_sc_hd__fill_1
XFILLER_7_173 VGND VGND VDPWR VDPWR sky130_fd_sc_hd__decap_3
XFILLER_7_179 VGND VGND VDPWR VDPWR sky130_fd_sc_hd__decap_4
XFILLER_7_211 VGND VGND VDPWR VDPWR sky130_fd_sc_hd__decap_12
XFILLER_7_223 VGND VGND VDPWR VDPWR sky130_fd_sc_hd__fill_1
XFILLER_7_225 VGND VGND VDPWR VDPWR sky130_fd_sc_hd__decap_12
XFILLER_7_237 VGND VGND VDPWR VDPWR sky130_fd_sc_hd__fill_2
XFILLER_7_259 VGND VGND VDPWR VDPWR sky130_fd_sc_hd__fill_1
XFILLER_7_27 VGND VGND VDPWR VDPWR sky130_fd_sc_hd__decap_8
XFILLER_7_299 VGND VGND VDPWR VDPWR sky130_fd_sc_hd__decap_8
XFILLER_7_3 VGND VGND VDPWR VDPWR sky130_fd_sc_hd__decap_12
XFILLER_7_307 VGND VGND VDPWR VDPWR sky130_fd_sc_hd__fill_2
XFILLER_7_317 VGND VGND VDPWR VDPWR sky130_fd_sc_hd__decap_3
XFILLER_7_35 VGND VGND VDPWR VDPWR sky130_fd_sc_hd__fill_1
XFILLER_7_52 VGND VGND VDPWR VDPWR sky130_fd_sc_hd__decap_4
XFILLER_7_57 VGND VGND VDPWR VDPWR sky130_fd_sc_hd__decap_12
XFILLER_7_69 VGND VGND VDPWR VDPWR sky130_fd_sc_hd__decap_6
XFILLER_7_85 VGND VGND VDPWR VDPWR sky130_fd_sc_hd__fill_1
XFILLER_7_92 VGND VGND VDPWR VDPWR sky130_fd_sc_hd__decap_12
XFILLER_8_108 VGND VGND VDPWR VDPWR sky130_fd_sc_hd__decap_4
XFILLER_8_130 VGND VGND VDPWR VDPWR sky130_fd_sc_hd__decap_8
XFILLER_8_138 VGND VGND VDPWR VDPWR sky130_fd_sc_hd__fill_2
XFILLER_8_141 VGND VGND VDPWR VDPWR sky130_fd_sc_hd__fill_1
XFILLER_8_15 VGND VGND VDPWR VDPWR sky130_fd_sc_hd__decap_12
XFILLER_8_170 VGND VGND VDPWR VDPWR sky130_fd_sc_hd__fill_1
XFILLER_8_181 VGND VGND VDPWR VDPWR sky130_fd_sc_hd__decap_8
XFILLER_8_189 VGND VGND VDPWR VDPWR sky130_fd_sc_hd__fill_1
XFILLER_8_193 VGND VGND VDPWR VDPWR sky130_fd_sc_hd__decap_3
XFILLER_8_197 VGND VGND VDPWR VDPWR sky130_fd_sc_hd__fill_1
XFILLER_8_201 VGND VGND VDPWR VDPWR sky130_fd_sc_hd__decap_8
XFILLER_8_209 VGND VGND VDPWR VDPWR sky130_fd_sc_hd__fill_2
XFILLER_8_231 VGND VGND VDPWR VDPWR sky130_fd_sc_hd__decap_8
XFILLER_8_239 VGND VGND VDPWR VDPWR sky130_fd_sc_hd__fill_2
XFILLER_8_248 VGND VGND VDPWR VDPWR sky130_fd_sc_hd__decap_4
XFILLER_8_253 VGND VGND VDPWR VDPWR sky130_fd_sc_hd__decap_12
XFILLER_8_265 VGND VGND VDPWR VDPWR sky130_fd_sc_hd__decap_3
XFILLER_8_27 VGND VGND VDPWR VDPWR sky130_fd_sc_hd__fill_1
XFILLER_8_288 VGND VGND VDPWR VDPWR sky130_fd_sc_hd__decap_8
XFILLER_8_296 VGND VGND VDPWR VDPWR sky130_fd_sc_hd__decap_3
XFILLER_8_3 VGND VGND VDPWR VDPWR sky130_fd_sc_hd__decap_12
XFILLER_8_303 VGND VGND VDPWR VDPWR sky130_fd_sc_hd__decap_4
XFILLER_8_307 VGND VGND VDPWR VDPWR sky130_fd_sc_hd__fill_1
XFILLER_8_317 VGND VGND VDPWR VDPWR sky130_fd_sc_hd__decap_3
XFILLER_8_56 VGND VGND VDPWR VDPWR sky130_fd_sc_hd__decap_12
XFILLER_8_68 VGND VGND VDPWR VDPWR sky130_fd_sc_hd__decap_6
XFILLER_8_74 VGND VGND VDPWR VDPWR sky130_fd_sc_hd__fill_1
XFILLER_8_85 VGND VGND VDPWR VDPWR sky130_fd_sc_hd__decap_6
XFILLER_8_91 VGND VGND VDPWR VDPWR sky130_fd_sc_hd__fill_1
XFILLER_8_96 VGND VGND VDPWR VDPWR sky130_fd_sc_hd__decap_12
XFILLER_9_127 VGND VGND VDPWR VDPWR sky130_fd_sc_hd__decap_4
XFILLER_9_140 VGND VGND VDPWR VDPWR sky130_fd_sc_hd__decap_12
XFILLER_9_15 VGND VGND VDPWR VDPWR sky130_fd_sc_hd__decap_12
XFILLER_9_152 VGND VGND VDPWR VDPWR sky130_fd_sc_hd__decap_12
XFILLER_9_169 VGND VGND VDPWR VDPWR sky130_fd_sc_hd__decap_3
XFILLER_9_180 VGND VGND VDPWR VDPWR sky130_fd_sc_hd__decap_12
XFILLER_9_192 VGND VGND VDPWR VDPWR sky130_fd_sc_hd__decap_8
XFILLER_9_200 VGND VGND VDPWR VDPWR sky130_fd_sc_hd__fill_2
XFILLER_9_209 VGND VGND VDPWR VDPWR sky130_fd_sc_hd__fill_2
XFILLER_9_218 VGND VGND VDPWR VDPWR sky130_fd_sc_hd__decap_6
XFILLER_9_225 VGND VGND VDPWR VDPWR sky130_fd_sc_hd__decap_8
XFILLER_9_233 VGND VGND VDPWR VDPWR sky130_fd_sc_hd__fill_1
XFILLER_9_241 VGND VGND VDPWR VDPWR sky130_fd_sc_hd__decap_6
XFILLER_9_262 VGND VGND VDPWR VDPWR sky130_fd_sc_hd__decap_6
XFILLER_9_268 VGND VGND VDPWR VDPWR sky130_fd_sc_hd__fill_1
XFILLER_9_27 VGND VGND VDPWR VDPWR sky130_fd_sc_hd__decap_8
XFILLER_9_277 VGND VGND VDPWR VDPWR sky130_fd_sc_hd__decap_3
XFILLER_9_281 VGND VGND VDPWR VDPWR sky130_fd_sc_hd__decap_8
XFILLER_9_289 VGND VGND VDPWR VDPWR sky130_fd_sc_hd__fill_2
XFILLER_9_3 VGND VGND VDPWR VDPWR sky130_fd_sc_hd__decap_12
XFILLER_9_315 VGND VGND VDPWR VDPWR sky130_fd_sc_hd__decap_4
XFILLER_9_319 VGND VGND VDPWR VDPWR sky130_fd_sc_hd__fill_1
XFILLER_9_35 VGND VGND VDPWR VDPWR sky130_fd_sc_hd__fill_1
XFILLER_9_57 VGND VGND VDPWR VDPWR sky130_fd_sc_hd__decap_3
XPHY_EDGE_ROW_0_Left_14 VGND VGND VDPWR VDPWR sky130_fd_sc_hd__decap_3
XPHY_EDGE_ROW_0_Right_0 VGND VGND VDPWR VDPWR sky130_fd_sc_hd__decap_3
XPHY_EDGE_ROW_10_Left_24 VGND VGND VDPWR VDPWR sky130_fd_sc_hd__decap_3
XPHY_EDGE_ROW_10_Right_10 VGND VGND VDPWR VDPWR sky130_fd_sc_hd__decap_3
XPHY_EDGE_ROW_11_Left_25 VGND VGND VDPWR VDPWR sky130_fd_sc_hd__decap_3
XPHY_EDGE_ROW_11_Right_11 VGND VGND VDPWR VDPWR sky130_fd_sc_hd__decap_3
XPHY_EDGE_ROW_12_Left_26 VGND VGND VDPWR VDPWR sky130_fd_sc_hd__decap_3
XPHY_EDGE_ROW_12_Right_12 VGND VGND VDPWR VDPWR sky130_fd_sc_hd__decap_3
XPHY_EDGE_ROW_13_Left_27 VGND VGND VDPWR VDPWR sky130_fd_sc_hd__decap_3
XPHY_EDGE_ROW_13_Right_13 VGND VGND VDPWR VDPWR sky130_fd_sc_hd__decap_3
XPHY_EDGE_ROW_1_Left_15 VGND VGND VDPWR VDPWR sky130_fd_sc_hd__decap_3
XPHY_EDGE_ROW_1_Right_1 VGND VGND VDPWR VDPWR sky130_fd_sc_hd__decap_3
XPHY_EDGE_ROW_2_Left_16 VGND VGND VDPWR VDPWR sky130_fd_sc_hd__decap_3
XPHY_EDGE_ROW_2_Right_2 VGND VGND VDPWR VDPWR sky130_fd_sc_hd__decap_3
XPHY_EDGE_ROW_3_Left_17 VGND VGND VDPWR VDPWR sky130_fd_sc_hd__decap_3
XPHY_EDGE_ROW_3_Right_3 VGND VGND VDPWR VDPWR sky130_fd_sc_hd__decap_3
XPHY_EDGE_ROW_4_Left_18 VGND VGND VDPWR VDPWR sky130_fd_sc_hd__decap_3
XPHY_EDGE_ROW_4_Right_4 VGND VGND VDPWR VDPWR sky130_fd_sc_hd__decap_3
XPHY_EDGE_ROW_5_Left_19 VGND VGND VDPWR VDPWR sky130_fd_sc_hd__decap_3
XPHY_EDGE_ROW_5_Right_5 VGND VGND VDPWR VDPWR sky130_fd_sc_hd__decap_3
XPHY_EDGE_ROW_6_Left_20 VGND VGND VDPWR VDPWR sky130_fd_sc_hd__decap_3
XPHY_EDGE_ROW_6_Right_6 VGND VGND VDPWR VDPWR sky130_fd_sc_hd__decap_3
XPHY_EDGE_ROW_7_Left_21 VGND VGND VDPWR VDPWR sky130_fd_sc_hd__decap_3
XPHY_EDGE_ROW_7_Right_7 VGND VGND VDPWR VDPWR sky130_fd_sc_hd__decap_3
XPHY_EDGE_ROW_8_Left_22 VGND VGND VDPWR VDPWR sky130_fd_sc_hd__decap_3
XPHY_EDGE_ROW_8_Right_8 VGND VGND VDPWR VDPWR sky130_fd_sc_hd__decap_3
XPHY_EDGE_ROW_9_Left_23 VGND VGND VDPWR VDPWR sky130_fd_sc_hd__decap_3
XPHY_EDGE_ROW_9_Right_9 VGND VGND VDPWR VDPWR sky130_fd_sc_hd__decap_3
XTAP_TAPCELL_ROW_0_28 VGND VDPWR sky130_fd_sc_hd__tapvpwrvgnd_1
XTAP_TAPCELL_ROW_0_29 VGND VDPWR sky130_fd_sc_hd__tapvpwrvgnd_1
XTAP_TAPCELL_ROW_0_30 VGND VDPWR sky130_fd_sc_hd__tapvpwrvgnd_1
XTAP_TAPCELL_ROW_0_31 VGND VDPWR sky130_fd_sc_hd__tapvpwrvgnd_1
XTAP_TAPCELL_ROW_0_32 VGND VDPWR sky130_fd_sc_hd__tapvpwrvgnd_1
XTAP_TAPCELL_ROW_0_33 VGND VDPWR sky130_fd_sc_hd__tapvpwrvgnd_1
XTAP_TAPCELL_ROW_0_34 VGND VDPWR sky130_fd_sc_hd__tapvpwrvgnd_1
XTAP_TAPCELL_ROW_0_35 VGND VDPWR sky130_fd_sc_hd__tapvpwrvgnd_1
XTAP_TAPCELL_ROW_0_36 VGND VDPWR sky130_fd_sc_hd__tapvpwrvgnd_1
XTAP_TAPCELL_ROW_0_37 VGND VDPWR sky130_fd_sc_hd__tapvpwrvgnd_1
XTAP_TAPCELL_ROW_0_38 VGND VDPWR sky130_fd_sc_hd__tapvpwrvgnd_1
XTAP_TAPCELL_ROW_10_88 VGND VDPWR sky130_fd_sc_hd__tapvpwrvgnd_1
XTAP_TAPCELL_ROW_10_89 VGND VDPWR sky130_fd_sc_hd__tapvpwrvgnd_1
XTAP_TAPCELL_ROW_10_90 VGND VDPWR sky130_fd_sc_hd__tapvpwrvgnd_1
XTAP_TAPCELL_ROW_10_91 VGND VDPWR sky130_fd_sc_hd__tapvpwrvgnd_1
XTAP_TAPCELL_ROW_10_92 VGND VDPWR sky130_fd_sc_hd__tapvpwrvgnd_1
XTAP_TAPCELL_ROW_10_93 VGND VDPWR sky130_fd_sc_hd__tapvpwrvgnd_1
XTAP_TAPCELL_ROW_11_94 VGND VDPWR sky130_fd_sc_hd__tapvpwrvgnd_1
XTAP_TAPCELL_ROW_11_95 VGND VDPWR sky130_fd_sc_hd__tapvpwrvgnd_1
XTAP_TAPCELL_ROW_11_96 VGND VDPWR sky130_fd_sc_hd__tapvpwrvgnd_1
XTAP_TAPCELL_ROW_11_97 VGND VDPWR sky130_fd_sc_hd__tapvpwrvgnd_1
XTAP_TAPCELL_ROW_11_98 VGND VDPWR sky130_fd_sc_hd__tapvpwrvgnd_1
XTAP_TAPCELL_ROW_12_100 VGND VDPWR sky130_fd_sc_hd__tapvpwrvgnd_1
XTAP_TAPCELL_ROW_12_101 VGND VDPWR sky130_fd_sc_hd__tapvpwrvgnd_1
XTAP_TAPCELL_ROW_12_102 VGND VDPWR sky130_fd_sc_hd__tapvpwrvgnd_1
XTAP_TAPCELL_ROW_12_103 VGND VDPWR sky130_fd_sc_hd__tapvpwrvgnd_1
XTAP_TAPCELL_ROW_12_104 VGND VDPWR sky130_fd_sc_hd__tapvpwrvgnd_1
XTAP_TAPCELL_ROW_12_99 VGND VDPWR sky130_fd_sc_hd__tapvpwrvgnd_1
XTAP_TAPCELL_ROW_13_105 VGND VDPWR sky130_fd_sc_hd__tapvpwrvgnd_1
XTAP_TAPCELL_ROW_13_106 VGND VDPWR sky130_fd_sc_hd__tapvpwrvgnd_1
XTAP_TAPCELL_ROW_13_107 VGND VDPWR sky130_fd_sc_hd__tapvpwrvgnd_1
XTAP_TAPCELL_ROW_13_108 VGND VDPWR sky130_fd_sc_hd__tapvpwrvgnd_1
XTAP_TAPCELL_ROW_13_109 VGND VDPWR sky130_fd_sc_hd__tapvpwrvgnd_1
XTAP_TAPCELL_ROW_13_110 VGND VDPWR sky130_fd_sc_hd__tapvpwrvgnd_1
XTAP_TAPCELL_ROW_13_111 VGND VDPWR sky130_fd_sc_hd__tapvpwrvgnd_1
XTAP_TAPCELL_ROW_13_112 VGND VDPWR sky130_fd_sc_hd__tapvpwrvgnd_1
XTAP_TAPCELL_ROW_13_113 VGND VDPWR sky130_fd_sc_hd__tapvpwrvgnd_1
XTAP_TAPCELL_ROW_13_114 VGND VDPWR sky130_fd_sc_hd__tapvpwrvgnd_1
XTAP_TAPCELL_ROW_13_115 VGND VDPWR sky130_fd_sc_hd__tapvpwrvgnd_1
XTAP_TAPCELL_ROW_1_39 VGND VDPWR sky130_fd_sc_hd__tapvpwrvgnd_1
XTAP_TAPCELL_ROW_1_40 VGND VDPWR sky130_fd_sc_hd__tapvpwrvgnd_1
XTAP_TAPCELL_ROW_1_41 VGND VDPWR sky130_fd_sc_hd__tapvpwrvgnd_1
XTAP_TAPCELL_ROW_1_42 VGND VDPWR sky130_fd_sc_hd__tapvpwrvgnd_1
XTAP_TAPCELL_ROW_1_43 VGND VDPWR sky130_fd_sc_hd__tapvpwrvgnd_1
XTAP_TAPCELL_ROW_2_44 VGND VDPWR sky130_fd_sc_hd__tapvpwrvgnd_1
XTAP_TAPCELL_ROW_2_45 VGND VDPWR sky130_fd_sc_hd__tapvpwrvgnd_1
XTAP_TAPCELL_ROW_2_46 VGND VDPWR sky130_fd_sc_hd__tapvpwrvgnd_1
XTAP_TAPCELL_ROW_2_47 VGND VDPWR sky130_fd_sc_hd__tapvpwrvgnd_1
XTAP_TAPCELL_ROW_2_48 VGND VDPWR sky130_fd_sc_hd__tapvpwrvgnd_1
XTAP_TAPCELL_ROW_2_49 VGND VDPWR sky130_fd_sc_hd__tapvpwrvgnd_1
XTAP_TAPCELL_ROW_3_50 VGND VDPWR sky130_fd_sc_hd__tapvpwrvgnd_1
XTAP_TAPCELL_ROW_3_51 VGND VDPWR sky130_fd_sc_hd__tapvpwrvgnd_1
XTAP_TAPCELL_ROW_3_52 VGND VDPWR sky130_fd_sc_hd__tapvpwrvgnd_1
XTAP_TAPCELL_ROW_3_53 VGND VDPWR sky130_fd_sc_hd__tapvpwrvgnd_1
XTAP_TAPCELL_ROW_3_54 VGND VDPWR sky130_fd_sc_hd__tapvpwrvgnd_1
XTAP_TAPCELL_ROW_4_55 VGND VDPWR sky130_fd_sc_hd__tapvpwrvgnd_1
XTAP_TAPCELL_ROW_4_56 VGND VDPWR sky130_fd_sc_hd__tapvpwrvgnd_1
XTAP_TAPCELL_ROW_4_57 VGND VDPWR sky130_fd_sc_hd__tapvpwrvgnd_1
XTAP_TAPCELL_ROW_4_58 VGND VDPWR sky130_fd_sc_hd__tapvpwrvgnd_1
XTAP_TAPCELL_ROW_4_59 VGND VDPWR sky130_fd_sc_hd__tapvpwrvgnd_1
XTAP_TAPCELL_ROW_4_60 VGND VDPWR sky130_fd_sc_hd__tapvpwrvgnd_1
XTAP_TAPCELL_ROW_5_61 VGND VDPWR sky130_fd_sc_hd__tapvpwrvgnd_1
XTAP_TAPCELL_ROW_5_62 VGND VDPWR sky130_fd_sc_hd__tapvpwrvgnd_1
XTAP_TAPCELL_ROW_5_63 VGND VDPWR sky130_fd_sc_hd__tapvpwrvgnd_1
XTAP_TAPCELL_ROW_5_64 VGND VDPWR sky130_fd_sc_hd__tapvpwrvgnd_1
XTAP_TAPCELL_ROW_5_65 VGND VDPWR sky130_fd_sc_hd__tapvpwrvgnd_1
XTAP_TAPCELL_ROW_6_66 VGND VDPWR sky130_fd_sc_hd__tapvpwrvgnd_1
XTAP_TAPCELL_ROW_6_67 VGND VDPWR sky130_fd_sc_hd__tapvpwrvgnd_1
XTAP_TAPCELL_ROW_6_68 VGND VDPWR sky130_fd_sc_hd__tapvpwrvgnd_1
XTAP_TAPCELL_ROW_6_69 VGND VDPWR sky130_fd_sc_hd__tapvpwrvgnd_1
XTAP_TAPCELL_ROW_6_70 VGND VDPWR sky130_fd_sc_hd__tapvpwrvgnd_1
XTAP_TAPCELL_ROW_6_71 VGND VDPWR sky130_fd_sc_hd__tapvpwrvgnd_1
XTAP_TAPCELL_ROW_7_72 VGND VDPWR sky130_fd_sc_hd__tapvpwrvgnd_1
XTAP_TAPCELL_ROW_7_73 VGND VDPWR sky130_fd_sc_hd__tapvpwrvgnd_1
XTAP_TAPCELL_ROW_7_74 VGND VDPWR sky130_fd_sc_hd__tapvpwrvgnd_1
XTAP_TAPCELL_ROW_7_75 VGND VDPWR sky130_fd_sc_hd__tapvpwrvgnd_1
XTAP_TAPCELL_ROW_7_76 VGND VDPWR sky130_fd_sc_hd__tapvpwrvgnd_1
XTAP_TAPCELL_ROW_8_77 VGND VDPWR sky130_fd_sc_hd__tapvpwrvgnd_1
XTAP_TAPCELL_ROW_8_78 VGND VDPWR sky130_fd_sc_hd__tapvpwrvgnd_1
XTAP_TAPCELL_ROW_8_79 VGND VDPWR sky130_fd_sc_hd__tapvpwrvgnd_1
XTAP_TAPCELL_ROW_8_80 VGND VDPWR sky130_fd_sc_hd__tapvpwrvgnd_1
XTAP_TAPCELL_ROW_8_81 VGND VDPWR sky130_fd_sc_hd__tapvpwrvgnd_1
XTAP_TAPCELL_ROW_8_82 VGND VDPWR sky130_fd_sc_hd__tapvpwrvgnd_1
XTAP_TAPCELL_ROW_9_83 VGND VDPWR sky130_fd_sc_hd__tapvpwrvgnd_1
XTAP_TAPCELL_ROW_9_84 VGND VDPWR sky130_fd_sc_hd__tapvpwrvgnd_1
XTAP_TAPCELL_ROW_9_85 VGND VDPWR sky130_fd_sc_hd__tapvpwrvgnd_1
XTAP_TAPCELL_ROW_9_86 VGND VDPWR sky130_fd_sc_hd__tapvpwrvgnd_1
XTAP_TAPCELL_ROW_9_87 VGND VDPWR sky130_fd_sc_hd__tapvpwrvgnd_1
X107 u_ctl.cfg[2] VGND VGND VDPWR VDPWR _094_ sky130_fd_sc_hd__inv_1
X108 net63 VGND VGND VDPWR VDPWR _095_ sky130_fd_sc_hd__inv_1
X109 net2 net1 VGND VGND VDPWR VDPWR u_ctl.arst_n sky130_fd_sc_hd__and2_0
X110 net54 u_ctl.state[0] VGND VGND VDPWR VDPWR net24 sky130_fd_sc_hd__nor2_1
X111 u_ctl.cnt[2] u_ctl.cnt[3] VGND VGND VDPWR VDPWR _096_ sky130_fd_sc_hd__nor2_1
X112 u_ctl.cnt[2] u_ctl.cnt[3] u_ctl.cnt[1] u_ctl.cnt[0] VGND VGND VDPWR VDPWR _097_ sky130_fd_sc_hd__nor4b_1
X113 u_ctl.cnt[1] _096_ u_ctl.cnt[0] VGND VGND VDPWR VDPWR _098_ sky130_fd_sc_hd__nand3b_1
X114 u_ctl.cfg[2] net5 VGND VGND VDPWR VDPWR _099_ sky130_fd_sc_hd__xor2_1
X115 u_ctl.a_req net7 VGND VGND VDPWR VDPWR _100_ sky130_fd_sc_hd__xor2_1
X116 net8 u_ctl.cfg[5] VGND VGND VDPWR VDPWR _101_ sky130_fd_sc_hd__xor2_1
X117 u_ctl.cfg[1] net4 VGND VGND VDPWR VDPWR _102_ sky130_fd_sc_hd__xor2_1
X118 u_ctl.cfg[0] net3 VGND VGND VDPWR VDPWR _103_ sky130_fd_sc_hd__xor2_1
X119 u_ctl.cfg[3] net6 VGND VGND VDPWR VDPWR _104_ sky130_fd_sc_hd__xor2_1
X120 net9 u_ctl.cfg[6] VGND VGND VDPWR VDPWR _105_ sky130_fd_sc_hd__xor2_1
X121 _099_ _100_ _102_ _104_ VGND VGND VDPWR VDPWR _035_ sky130_fd_sc_hd__nor4_1
X122 _101_ _103_ _105_ VGND VGND VDPWR VDPWR _036_ sky130_fd_sc_hd__nor3_1
X123 u_ctl.apply_s[2] u_ctl.apply_s[1] VGND VGND VDPWR VDPWR _037_ sky130_fd_sc_hd__nor2b_1
X124 net24 _037_ VGND VGND VDPWR VDPWR _038_ sky130_fd_sc_hd__nor2b_1
X125 net54 u_ctl.state[0] _037_ VGND VGND VDPWR VDPWR _039_ sky130_fd_sc_hd__o21ai_1
X126 net53 net41 _036_ _039_ VGND VGND VDPWR VDPWR _040_ sky130_fd_sc_hd__nand4_1
X127 _098_ _040_ VGND VGND VDPWR VDPWR _001_ sky130_fd_sc_hd__nor2_1
X128 _037_ net73 VGND VGND VDPWR VDPWR _000_ sky130_fd_sc_hd__nor2b_1
X129 u_ctl.div[0] u_ctl.div[1] u_ctl.div[2] u_ctl.div[3] u_ctl.cfg[5] u_ctl.cfg[6] VGND VGND VDPWR VDPWR _041_ sky130_fd_sc_hd__mux4_2
X130 u_ctl.agg_en _041_ VGND VGND VDPWR VDPWR _006_ sky130_fd_sc_hd__and2_0
X131 u_ctl.cfg[2] net54 VGND VGND VDPWR VDPWR net27 sky130_fd_sc_hd__and2_0
X132 net76 _098_ net38 VGND VGND VDPWR VDPWR _042_ sky130_fd_sc_hd__a21oi_1
X133 _042_ VGND VGND VDPWR VDPWR _005_ sky130_fd_sc_hd__inv_1
X134 u_ctl.cnt[0] u_ctl.cnt[1] _096_ VGND VGND VDPWR VDPWR _043_ sky130_fd_sc_hd__nand3_1
X135 u_ctl.state[3] _043_ VGND VGND VDPWR VDPWR _044_ sky130_fd_sc_hd__nand2_1
X136 net76 net44 VGND VGND VDPWR VDPWR _045_ sky130_fd_sc_hd__nand2_1
X137 _044_ _045_ net38 VGND VGND VDPWR VDPWR _004_ sky130_fd_sc_hd__a21oi_1
X138 net53 _098_ net37 VGND VGND VDPWR VDPWR _046_ sky130_fd_sc_hd__nand3_1
X139 u_ctl.cnt[0] u_ctl.cnt[1] u_ctl.state[3] _096_ VGND VGND VDPWR VDPWR _047_ sky130_fd_sc_hd__nand4_1
X140 net38 _047_ _046_ VGND VGND VDPWR VDPWR _003_ sky130_fd_sc_hd__o21ai_0
X141 net53 net43 VGND VGND VDPWR VDPWR _048_ sky130_fd_sc_hd__nand2_1
X142 net40 _036_ _048_ VGND VGND VDPWR VDPWR _049_ sky130_fd_sc_hd__a21oi_1
X143 net54 u_ctl.state[5] _049_ VGND VGND VDPWR VDPWR _050_ sky130_fd_sc_hd__nor3_1
X144 net38 _050_ VGND VGND VDPWR VDPWR _002_ sky130_fd_sc_hd__nor2_1
X145 net69 u_ctl.agg_en VGND VGND VDPWR VDPWR _007_ sky130_fd_sc_hd__nor2b_1
X146 u_ctl.div[0] net66 u_ctl.agg_en VGND VGND VDPWR VDPWR _051_ sky130_fd_sc_hd__o21ai_0
X147 u_ctl.div[0] net66 _051_ VGND VGND VDPWR VDPWR _008_ sky130_fd_sc_hd__a21oi_1
X148 u_ctl.div[0] u_ctl.div[1] net77 VGND VGND VDPWR VDPWR _052_ sky130_fd_sc_hd__a21oi_1
X149 u_ctl.div[2] u_ctl.div[0] u_ctl.div[1] VGND VGND VDPWR VDPWR _053_ sky130_fd_sc_hd__and3_1
X150 _052_ _053_ u_ctl.agg_en VGND VGND VDPWR VDPWR _009_ sky130_fd_sc_hd__nor3b_1
X151 net58 _053_ u_ctl.agg_en VGND VGND VDPWR VDPWR _054_ sky130_fd_sc_hd__o21ai_0
X152 net58 _053_ _054_ VGND VGND VDPWR VDPWR _010_ sky130_fd_sc_hd__a21oi_1
X153 u_ctl.cfg[0] net54 VGND VGND VDPWR VDPWR net25 sky130_fd_sc_hd__and2_0
X154 u_ctl.cfg[1] net54 VGND VGND VDPWR VDPWR net26 sky130_fd_sc_hd__and2_0
X155 net53 u_ctl.state[4] u_ctl.state[3] VGND VGND VDPWR VDPWR _055_ sky130_fd_sc_hd__nor3_1
X156 u_ctl.cnt[0] net38 _055_ VGND VGND VDPWR VDPWR _056_ sky130_fd_sc_hd__or3_1
X157 net37 net42 VGND VGND VDPWR VDPWR _057_ sky130_fd_sc_hd__nand2_1
X158 u_ctl.cnt[0] net37 net42 VGND VGND VDPWR VDPWR _058_ sky130_fd_sc_hd__nand3_1
X159 _056_ _058_ VGND VGND VDPWR VDPWR _011_ sky130_fd_sc_hd__nand2_1
X160 _056_ _057_ u_ctl.cnt[1] VGND VGND VDPWR VDPWR _059_ sky130_fd_sc_hd__a21bo_1
X161 u_ctl.cnt[2] u_ctl.cnt[3] u_ctl.state[3] u_ctl.cnt[0] VGND VGND VDPWR VDPWR _060_ sky130_fd_sc_hd__o31ai_1
X162 u_ctl.cnt[1] net38 _055_ _060_ _059_ VGND VGND VDPWR VDPWR _012_ sky130_fd_sc_hd__o41ai_1
X163 u_ctl.cnt[0] u_ctl.cnt[1] _057_ u_ctl.cnt[2] VGND VGND VDPWR VDPWR _061_ sky130_fd_sc_hd__a31oi_1
X164 u_ctl.cnt[2] u_ctl.cnt[0] u_ctl.cnt[1] VGND VGND VDPWR VDPWR _062_ sky130_fd_sc_hd__nand3_1
X165 net42 _062_ VGND VGND VDPWR VDPWR _063_ sky130_fd_sc_hd__nor2_1
X166 net37 _047_ VGND VGND VDPWR VDPWR _064_ sky130_fd_sc_hd__nand2_1
X167 _061_ _063_ _064_ VGND VGND VDPWR VDPWR _013_ sky130_fd_sc_hd__nor3_1
X168 u_ctl.cnt[3] _063_ net37 VGND VGND VDPWR VDPWR _065_ sky130_fd_sc_hd__o21ai_0
X169 net70 _063_ _065_ VGND VGND VDPWR VDPWR _014_ sky130_fd_sc_hd__a21oi_1
X170 net38 _049_ VGND VGND VDPWR VDPWR _066_ sky130_fd_sc_hd__nor2_1
X171 net3 net38 net35 u_ctl.cfg[0] VGND VGND VDPWR VDPWR _015_ sky130_fd_sc_hd__a22o_1
X172 net4 net38 net35 u_ctl.cfg[1] VGND VGND VDPWR VDPWR _016_ sky130_fd_sc_hd__a22o_1
X173 net5 net39 net35 u_ctl.cfg[2] VGND VGND VDPWR VDPWR _017_ sky130_fd_sc_hd__a22o_1
X174 net6 net39 VGND VGND VDPWR VDPWR _067_ sky130_fd_sc_hd__nand2_1
X175 u_ctl.cfg[3] _039_ VGND VGND VDPWR VDPWR _068_ sky130_fd_sc_hd__nand2_1
X176 _049_ _068_ _067_ VGND VGND VDPWR VDPWR _018_ sky130_fd_sc_hd__o21ai_0
X177 net7 net39 _066_ net78 VGND VGND VDPWR VDPWR _019_ sky130_fd_sc_hd__a22o_1
X178 net8 net39 net35 net79 VGND VGND VDPWR VDPWR _020_ sky130_fd_sc_hd__a22o_1
X179 net9 net39 net35 net75 VGND VGND VDPWR VDPWR _021_ sky130_fd_sc_hd__a22o_1
X180 u_ctl.cfg[1] u_ctl.cfg[0] VGND VGND VDPWR VDPWR _069_ sky130_fd_sc_hd__nand2b_1
X181 u_ctl.cfg[0] u_ctl.cfg[1] VGND VGND VDPWR VDPWR _070_ sky130_fd_sc_hd__nand2b_1
X182 _069_ _070_ VGND VGND VDPWR VDPWR _071_ sky130_fd_sc_hd__nand2_1
X183 _037_ net54 VGND VGND VDPWR VDPWR _072_ sky130_fd_sc_hd__nor2b_1
X184 u_ctl.cfg[1] u_ctl.cfg[0] VGND VGND VDPWR VDPWR _073_ sky130_fd_sc_hd__and2_0
X185 u_ctl.cfg[1] u_ctl.cfg[0] VGND VGND VDPWR VDPWR _074_ sky130_fd_sc_hd__nand2_1
X186 u_ctl.cfg[3] _069_ _070_ _074_ u_ctl.a_req VGND VGND VDPWR VDPWR _075_ sky130_fd_sc_hd__a32oi_1
X187 net54 net39 VGND VGND VDPWR VDPWR _076_ sky130_fd_sc_hd__nor2_1
X188 u_ctl.state[0] _037_ net53 net54 VGND VGND VDPWR VDPWR _077_ sky130_fd_sc_hd__a211oi_1
X189 _072_ _075_ _077_ VGND VGND VDPWR VDPWR _078_ sky130_fd_sc_hd__a21oi_1
X190 _040_ _046_ _078_ net68 VGND VGND VDPWR VDPWR _079_ sky130_fd_sc_hd__a31oi_1
X191 net38 _079_ VGND VGND VDPWR VDPWR _022_ sky130_fd_sc_hd__nor2_1
X192 net78 _072_ _073_ _076_ u_ctl.agg_en VGND VGND VDPWR VDPWR _023_ sky130_fd_sc_hd__a32o_1
X193 u_ctl.state[5] u_ctl.state[4] _042_ VGND VGND VDPWR VDPWR _080_ sky130_fd_sc_hd__o21ai_0
X194 u_ctl.cfg[2] _069_ VGND VGND VDPWR VDPWR _081_ sky130_fd_sc_hd__nor2_1
X195 u_ctl.state[5] net36 _081_ net33 net65 VGND VGND VDPWR VDPWR _024_ sky130_fd_sc_hd__a32o_1
X196 _094_ _069_ VGND VGND VDPWR VDPWR _082_ sky130_fd_sc_hd__nor2_1
X197 u_ctl.state[5] net36 _082_ net33 net62 VGND VGND VDPWR VDPWR _025_ sky130_fd_sc_hd__a32o_1
X198 u_ctl.cfg[2] _070_ VGND VGND VDPWR VDPWR _083_ sky130_fd_sc_hd__nor2_1
X199 u_ctl.state[5] net36 _083_ net33 net60 VGND VGND VDPWR VDPWR _026_ sky130_fd_sc_hd__a32o_1
X200 _094_ _070_ VGND VGND VDPWR VDPWR _084_ sky130_fd_sc_hd__nor2_1
X201 u_ctl.state[5] net36 _084_ net34 net61 VGND VGND VDPWR VDPWR _027_ sky130_fd_sc_hd__a32o_1
X202 u_ctl.state[5] _042_ _073_ _080_ net59 VGND VGND VDPWR VDPWR _028_ sky130_fd_sc_hd__a32o_1
X203 net53 u_ctl.state[3] VGND VGND VDPWR VDPWR _085_ sky130_fd_sc_hd__nor2b_1
X204 _049_ _085_ _039_ _044_ VGND VGND VDPWR VDPWR _086_ sky130_fd_sc_hd__o211ai_1
X205 u_ctl.cfg[2] net53 _069_ VGND VGND VDPWR VDPWR _087_ sky130_fd_sc_hd__or3_1
X206 _087_ net13 _086_ VGND VGND VDPWR VDPWR _029_ sky130_fd_sc_hd__mux2_1
X207 _094_ net53 _069_ VGND VGND VDPWR VDPWR _088_ sky130_fd_sc_hd__or3_1
X208 _088_ net12 net32 VGND VGND VDPWR VDPWR _030_ sky130_fd_sc_hd__mux2_1
X209 u_ctl.cfg[2] net53 _070_ VGND VGND VDPWR VDPWR _089_ sky130_fd_sc_hd__or3_1
X210 _089_ net16 net32 VGND VGND VDPWR VDPWR _031_ sky130_fd_sc_hd__mux2_1
X211 _094_ net53 _070_ VGND VGND VDPWR VDPWR _090_ sky130_fd_sc_hd__or3_1
X212 _090_ net15 net31 VGND VGND VDPWR VDPWR _032_ sky130_fd_sc_hd__mux2_1
X213 u_ctl.state[2] _074_ VGND VGND VDPWR VDPWR _091_ sky130_fd_sc_hd__nor2_1
X214 _091_ _095_ net31 VGND VGND VDPWR VDPWR _033_ sky130_fd_sc_hd__mux2i_1
X215 net22 _076_ VGND VGND VDPWR VDPWR _092_ sky130_fd_sc_hd__nand2_1
X216 net71 _071_ VGND VGND VDPWR VDPWR _093_ sky130_fd_sc_hd__nand2_1
X217 _068_ _093_ _092_ VGND VGND VDPWR VDPWR _034_ sky130_fd_sc_hd__o21ai_0
X218 clknet_3_0__leaf_clk _024_ net48 VGND VGND VDPWR VDPWR net18 sky130_fd_sc_hd__dfrtp_1
X219 clknet_3_0__leaf_clk _025_ net48 VGND VGND VDPWR VDPWR net17 sky130_fd_sc_hd__dfrtp_1
X220 clknet_3_0__leaf_clk _026_ net47 VGND VGND VDPWR VDPWR net21 sky130_fd_sc_hd__dfrtp_1
X221 clknet_3_1__leaf_clk _027_ net47 VGND VGND VDPWR VDPWR net20 sky130_fd_sc_hd__dfrtp_1
X222 clknet_3_1__leaf_clk _028_ net46 VGND VGND VDPWR VDPWR net19 sky130_fd_sc_hd__dfrtp_1
X223 clknet_3_1__leaf_clk _029_ net46 VGND VGND VDPWR VDPWR net13 sky130_fd_sc_hd__dfstp_1
X224 clknet_3_4__leaf_clk _030_ net46 VGND VGND VDPWR VDPWR net12 sky130_fd_sc_hd__dfstp_1
X225 clknet_3_4__leaf_clk _031_ net50 VGND VGND VDPWR VDPWR net16 sky130_fd_sc_hd__dfstp_1
X226 clknet_3_4__leaf_clk _032_ net50 VGND VGND VDPWR VDPWR net15 sky130_fd_sc_hd__dfstp_1
X227 clknet_3_5__leaf_clk net64 net50 VGND VGND VDPWR VDPWR net14 sky130_fd_sc_hd__dfstp_1
X228 clknet_3_4__leaf_clk net72 net50 VGND VGND VDPWR VDPWR net22 sky130_fd_sc_hd__dfrtp_1
X229 clknet_3_0__leaf_clk _011_ net48 VGND VGND VDPWR VDPWR u_ctl.cnt[0] sky130_fd_sc_hd__dfrtp_1
X230 clknet_3_0__leaf_clk _012_ net47 VGND VGND VDPWR VDPWR u_ctl.cnt[1] sky130_fd_sc_hd__dfrtp_1
X231 clknet_3_2__leaf_clk _013_ net48 VGND VGND VDPWR VDPWR u_ctl.cnt[2] sky130_fd_sc_hd__dfrtp_1
X232 clknet_3_2__leaf_clk _014_ net48 VGND VGND VDPWR VDPWR u_ctl.cnt[3] sky130_fd_sc_hd__dfrtp_1
X233 clknet_3_6__leaf_clk _015_ net49 VGND VGND VDPWR VDPWR u_ctl.cfg[0] sky130_fd_sc_hd__dfrtp_1
X234 clknet_3_6__leaf_clk _016_ net50 VGND VGND VDPWR VDPWR u_ctl.cfg[1] sky130_fd_sc_hd__dfrtp_1
X235 clknet_3_5__leaf_clk _017_ net50 VGND VGND VDPWR VDPWR u_ctl.cfg[2] sky130_fd_sc_hd__dfrtp_1
X236 clknet_3_4__leaf_clk _018_ net50 VGND VGND VDPWR VDPWR u_ctl.cfg[3] sky130_fd_sc_hd__dfrtp_1
X237 clknet_3_6__leaf_clk _019_ net50 VGND VGND VDPWR VDPWR u_ctl.a_req sky130_fd_sc_hd__dfrtp_1
X238 clknet_3_6__leaf_clk _020_ net49 VGND VGND VDPWR VDPWR u_ctl.cfg[5] sky130_fd_sc_hd__dfrtp_1
X239 clknet_3_5__leaf_clk _021_ net51 VGND VGND VDPWR VDPWR u_ctl.cfg[6] sky130_fd_sc_hd__dfrtp_1
X240 clknet_3_2__leaf_clk _022_ net48 VGND VGND VDPWR VDPWR u_ctl.err sky130_fd_sc_hd__dfrtp_1
X241 clknet_3_3__leaf_clk _023_ net46 VGND VGND VDPWR VDPWR u_ctl.agg_en sky130_fd_sc_hd__dfrtp_1
X242 clknet_3_3__leaf_clk net74 net45 VGND VGND VDPWR VDPWR u_ctl.state[0] sky130_fd_sc_hd__dfstp_1
X243 clknet_3_1__leaf_clk _002_ net46 VGND VGND VDPWR VDPWR u_ctl.active sky130_fd_sc_hd__dfrtp_1
X244 clknet_3_2__leaf_clk _003_ net47 VGND VGND VDPWR VDPWR u_ctl.state[2] sky130_fd_sc_hd__dfrtp_1
X245 clknet_3_3__leaf_clk _004_ net46 VGND VGND VDPWR VDPWR u_ctl.state[3] sky130_fd_sc_hd__dfrtp_1
X246 clknet_3_2__leaf_clk _005_ net46 VGND VGND VDPWR VDPWR u_ctl.state[4] sky130_fd_sc_hd__dfrtp_1
X247 clknet_3_1__leaf_clk _001_ net46 VGND VGND VDPWR VDPWR u_ctl.state[5] sky130_fd_sc_hd__dfrtp_1
X248 clknet_3_3__leaf_clk net10 net45 VGND VGND VDPWR VDPWR u_ctl.apply_s[0] sky130_fd_sc_hd__dfrtp_1
X249 clknet_3_3__leaf_clk net55 net52 VGND VGND VDPWR VDPWR u_ctl.apply_s[1] sky130_fd_sc_hd__dfrtp_1
X250 clknet_3_6__leaf_clk net57 net52 VGND VGND VDPWR VDPWR u_ctl.apply_s[2] sky130_fd_sc_hd__dfrtp_1
X251 clknet_3_7__leaf_clk net u_ctl.arst_n VGND VGND VDPWR VDPWR u_ctl.rsync[0] sky130_fd_sc_hd__dfrtp_1
X251__55 VGND VGND VDPWR VDPWR net nc_251__55_LO sky130_fd_sc_hd__conb_1
X252 clknet_3_7__leaf_clk net56 u_ctl.arst_n VGND VGND VDPWR VDPWR u_ctl.rstn_i sky130_fd_sc_hd__dfrtp_1
X253 clknet_3_5__leaf_clk _007_ net51 VGND VGND VDPWR VDPWR u_ctl.div[0] sky130_fd_sc_hd__dfrtp_1
X254 clknet_3_7__leaf_clk net67 net51 VGND VGND VDPWR VDPWR u_ctl.div[1] sky130_fd_sc_hd__dfrtp_1
X255 clknet_3_7__leaf_clk _009_ net51 VGND VGND VDPWR VDPWR u_ctl.div[2] sky130_fd_sc_hd__dfrtp_1
X256 clknet_3_7__leaf_clk _010_ net51 VGND VGND VDPWR VDPWR u_ctl.div[3] sky130_fd_sc_hd__dfrtp_1
X257 clknet_3_5__leaf_clk _006_ net51 VGND VGND VDPWR VDPWR net11 sky130_fd_sc_hd__dfrtp_1
X259 net54 VGND VGND VDPWR VDPWR net23 sky130_fd_sc_hd__buf_2
X260 net22 VGND VGND VDPWR VDPWR net28 sky130_fd_sc_hd__buf_2
X261 u_ctl.agg_en VGND VGND VDPWR VDPWR net29 sky130_fd_sc_hd__buf_2
X262 u_ctl.err VGND VGND VDPWR VDPWR net30 sky130_fd_sc_hd__buf_2
Xclkbuf_0_clk clk VGND VGND VDPWR VDPWR clknet_0_clk sky130_fd_sc_hd__clkbuf_16
Xclkbuf_3_0__f_clk clknet_0_clk VGND VGND VDPWR VDPWR clknet_3_0__leaf_clk sky130_fd_sc_hd__clkbuf_16
Xclkbuf_3_1__f_clk clknet_0_clk VGND VGND VDPWR VDPWR clknet_3_1__leaf_clk sky130_fd_sc_hd__clkbuf_16
Xclkbuf_3_2__f_clk clknet_0_clk VGND VGND VDPWR VDPWR clknet_3_2__leaf_clk sky130_fd_sc_hd__clkbuf_16
Xclkbuf_3_3__f_clk clknet_0_clk VGND VGND VDPWR VDPWR clknet_3_3__leaf_clk sky130_fd_sc_hd__clkbuf_16
Xclkbuf_3_4__f_clk clknet_0_clk VGND VGND VDPWR VDPWR clknet_3_4__leaf_clk sky130_fd_sc_hd__clkbuf_16
Xclkbuf_3_5__f_clk clknet_0_clk VGND VGND VDPWR VDPWR clknet_3_5__leaf_clk sky130_fd_sc_hd__clkbuf_16
Xclkbuf_3_6__f_clk clknet_0_clk VGND VGND VDPWR VDPWR clknet_3_6__leaf_clk sky130_fd_sc_hd__clkbuf_16
Xclkbuf_3_7__f_clk clknet_0_clk VGND VGND VDPWR VDPWR clknet_3_7__leaf_clk sky130_fd_sc_hd__clkbuf_16
Xclkload0 clknet_3_1__leaf_clk VGND VGND VDPWR VDPWR nc_clkload0_X sky130_fd_sc_hd__clkbuf_1
Xclkload1 clknet_3_3__leaf_clk VGND VGND VDPWR VDPWR nc_clkload1_X sky130_fd_sc_hd__clkbuf_1
Xclkload2 clknet_3_4__leaf_clk VGND VGND VDPWR VDPWR nc_clkload2_X sky130_fd_sc_hd__clkbuf_1
Xclkload3 clknet_3_5__leaf_clk VGND VGND VDPWR VDPWR nc_clkload3_X sky130_fd_sc_hd__clkbuf_1
Xfanout38 _038_ VGND VGND VDPWR VDPWR net38 sky130_fd_sc_hd__clkdlybuf4s50_1
Xfanout39 _038_ VGND VGND VDPWR VDPWR net39 sky130_fd_sc_hd__clkdlybuf4s50_1
Xfanout45 net52 VGND VGND VDPWR VDPWR net45 sky130_fd_sc_hd__clkdlybuf4s50_1
Xfanout47 net52 VGND VGND VDPWR VDPWR net47 sky130_fd_sc_hd__clkdlybuf4s50_1
Xfanout49 net52 VGND VGND VDPWR VDPWR net49 sky130_fd_sc_hd__clkdlybuf4s50_1
Xfanout51 net52 VGND VGND VDPWR VDPWR net51 sky130_fd_sc_hd__clkdlybuf4s50_1
Xfanout52 net80 VGND VGND VDPWR VDPWR net52 sky130_fd_sc_hd__clkdlybuf4s50_1
Xfanout53 u_ctl.state[2] VGND VGND VDPWR VDPWR net53 sky130_fd_sc_hd__clkdlybuf4s50_1
Xfanout54 u_ctl.active VGND VGND VDPWR VDPWR net54 sky130_fd_sc_hd__clkdlybuf4s50_1
Xhold56 u_ctl.apply_s[0] VGND VGND VDPWR VDPWR net55 sky130_fd_sc_hd__dlygate4sd3_1
Xhold57 u_ctl.rsync[0] VGND VGND VDPWR VDPWR net56 sky130_fd_sc_hd__dlygate4sd3_1
Xhold58 u_ctl.apply_s[1] VGND VGND VDPWR VDPWR net57 sky130_fd_sc_hd__dlygate4sd3_1
Xhold59 u_ctl.div[3] VGND VGND VDPWR VDPWR net58 sky130_fd_sc_hd__dlygate4sd3_1
Xhold60 net19 VGND VGND VDPWR VDPWR net59 sky130_fd_sc_hd__dlygate4sd3_1
Xhold61 net21 VGND VGND VDPWR VDPWR net60 sky130_fd_sc_hd__dlygate4sd3_1
Xhold62 net20 VGND VGND VDPWR VDPWR net61 sky130_fd_sc_hd__dlygate4sd3_1
Xhold63 net17 VGND VGND VDPWR VDPWR net62 sky130_fd_sc_hd__dlygate4sd3_1
Xhold64 net14 VGND VGND VDPWR VDPWR net63 sky130_fd_sc_hd__dlygate4sd3_1
Xhold65 _033_ VGND VGND VDPWR VDPWR net64 sky130_fd_sc_hd__dlygate4sd3_1
Xhold66 net18 VGND VGND VDPWR VDPWR net65 sky130_fd_sc_hd__dlygate4sd3_1
Xhold67 u_ctl.div[1] VGND VGND VDPWR VDPWR net66 sky130_fd_sc_hd__dlygate4sd3_1
Xhold68 _008_ VGND VGND VDPWR VDPWR net67 sky130_fd_sc_hd__dlygate4sd3_1
Xhold69 u_ctl.err VGND VGND VDPWR VDPWR net68 sky130_fd_sc_hd__dlygate4sd3_1
Xhold70 u_ctl.div[0] VGND VGND VDPWR VDPWR net69 sky130_fd_sc_hd__dlygate4sd3_1
Xhold71 u_ctl.cnt[3] VGND VGND VDPWR VDPWR net70 sky130_fd_sc_hd__dlygate4sd3_1
Xhold72 u_ctl.active VGND VGND VDPWR VDPWR net71 sky130_fd_sc_hd__dlygate4sd3_1
Xhold73 _034_ VGND VGND VDPWR VDPWR net72 sky130_fd_sc_hd__dlygate4sd3_1
Xhold74 u_ctl.state[0] VGND VGND VDPWR VDPWR net73 sky130_fd_sc_hd__dlygate4sd3_1
Xhold75 _000_ VGND VGND VDPWR VDPWR net74 sky130_fd_sc_hd__dlygate4sd3_1
Xhold76 u_ctl.cfg[6] VGND VGND VDPWR VDPWR net75 sky130_fd_sc_hd__dlygate4sd3_1
Xhold77 u_ctl.state[4] VGND VGND VDPWR VDPWR net76 sky130_fd_sc_hd__dlygate4sd3_1
Xhold78 u_ctl.div[2] VGND VGND VDPWR VDPWR net77 sky130_fd_sc_hd__dlygate4sd3_1
Xhold79 u_ctl.a_req VGND VGND VDPWR VDPWR net78 sky130_fd_sc_hd__dlygate4sd3_1
Xhold80 u_ctl.cfg[5] VGND VGND VDPWR VDPWR net79 sky130_fd_sc_hd__dlygate4sd3_1
Xhold81 u_ctl.rstn_i VGND VGND VDPWR VDPWR net80 sky130_fd_sc_hd__dlygate4sd3_1
Xinput1 ena VGND VGND VDPWR VDPWR net1 sky130_fd_sc_hd__buf_2
Xinput10 ui_in[7] VGND VGND VDPWR VDPWR net10 sky130_fd_sc_hd__buf_2
Xinput2 rst_n VGND VGND VDPWR VDPWR net2 sky130_fd_sc_hd__buf_2
Xinput3 ui_in[0] VGND VGND VDPWR VDPWR net3 sky130_fd_sc_hd__buf_2
Xinput4 ui_in[1] VGND VGND VDPWR VDPWR net4 sky130_fd_sc_hd__buf_2
Xinput5 ui_in[2] VGND VGND VDPWR VDPWR net5 sky130_fd_sc_hd__buf_2
Xinput6 ui_in[3] VGND VGND VDPWR VDPWR net6 sky130_fd_sc_hd__buf_2
Xinput7 ui_in[4] VGND VGND VDPWR VDPWR net7 sky130_fd_sc_hd__buf_2
Xinput8 ui_in[5] VGND VGND VDPWR VDPWR net8 sky130_fd_sc_hd__buf_2
Xinput9 ui_in[6] VGND VGND VDPWR VDPWR net9 sky130_fd_sc_hd__buf_2
Xload_slew46 net45 VGND VGND VDPWR VDPWR net46 sky130_fd_sc_hd__buf_4
Xload_slew48 net47 VGND VGND VDPWR VDPWR net48 sky130_fd_sc_hd__buf_2
Xload_slew50 net49 VGND VGND VDPWR VDPWR net50 sky130_fd_sc_hd__clkbuf_4
Xmax_cap31 net32 VGND VGND VDPWR VDPWR net31 sky130_fd_sc_hd__buf_1
Xmax_cap32 _086_ VGND VGND VDPWR VDPWR net32 sky130_fd_sc_hd__buf_1
Xmax_cap34 _080_ VGND VGND VDPWR VDPWR net34 sky130_fd_sc_hd__clkdlybuf4s25_1
Xmax_cap35 _066_ VGND VGND VDPWR VDPWR net35 sky130_fd_sc_hd__clkbuf_2
Xmax_cap36 _042_ VGND VGND VDPWR VDPWR net36 sky130_fd_sc_hd__buf_1
Xmax_cap37 _039_ VGND VGND VDPWR VDPWR net37 sky130_fd_sc_hd__clkbuf_2
Xmax_cap40 net41 VGND VGND VDPWR VDPWR net40 sky130_fd_sc_hd__clkdlybuf4s25_1
Xmax_cap42 _055_ VGND VGND VDPWR VDPWR net42 sky130_fd_sc_hd__clkdlybuf4s25_1
Xmax_cap43 net44 VGND VGND VDPWR VDPWR net43 sky130_fd_sc_hd__clkdlybuf4s25_1
Xoutput11 net11 VGND VGND VDPWR VDPWR agg_clk sky130_fd_sc_hd__buf_2
Xoutput12 net12 VGND VGND VDPWR VDPWR clr_mc sky130_fd_sc_hd__buf_2
Xoutput13 net13 VGND VGND VDPWR VDPWR clr_mg sky130_fd_sc_hd__buf_2
Xoutput14 net14 VGND VGND VDPWR VDPWR clr_n sky130_fd_sc_hd__buf_2
Xoutput15 net15 VGND VGND VDPWR VDPWR clr_pc sky130_fd_sc_hd__buf_2
Xoutput16 net16 VGND VGND VDPWR VDPWR clr_pg sky130_fd_sc_hd__buf_2
Xoutput17 net17 VGND VGND VDPWR VDPWR en_mc sky130_fd_sc_hd__buf_2
Xoutput18 net18 VGND VGND VDPWR VDPWR en_mg sky130_fd_sc_hd__buf_2
Xoutput19 net19 VGND VGND VDPWR VDPWR en_n sky130_fd_sc_hd__buf_2
Xoutput20 net20 VGND VGND VDPWR VDPWR en_pc sky130_fd_sc_hd__buf_2
Xoutput21 net21 VGND VGND VDPWR VDPWR en_pg sky130_fd_sc_hd__buf_2
Xoutput22 net22 VGND VGND VDPWR VDPWR hen sky130_fd_sc_hd__buf_2
Xoutput23 net23 VGND VGND VDPWR VDPWR status[0] sky130_fd_sc_hd__buf_2
Xoutput24 net24 VGND VGND VDPWR VDPWR status[1] sky130_fd_sc_hd__buf_2
Xoutput25 net25 VGND VGND VDPWR VDPWR status[2] sky130_fd_sc_hd__buf_2
Xoutput26 net26 VGND VGND VDPWR VDPWR status[3] sky130_fd_sc_hd__buf_2
Xoutput27 net27 VGND VGND VDPWR VDPWR status[4] sky130_fd_sc_hd__buf_2
Xoutput28 net28 VGND VGND VDPWR VDPWR status[5] sky130_fd_sc_hd__buf_2
Xoutput29 net29 VGND VGND VDPWR VDPWR status[6] sky130_fd_sc_hd__buf_2
Xoutput30 net30 VGND VGND VDPWR VDPWR status[7] sky130_fd_sc_hd__buf_2
Xwire33 net34 VGND VGND VDPWR VDPWR net33 sky130_fd_sc_hd__clkdlybuf4s25_1
Xwire41 _035_ VGND VGND VDPWR VDPWR net41 sky130_fd_sc_hd__clkdlybuf4s25_1
Xwire44 _097_ VGND VGND VDPWR VDPWR net44 sky130_fd_sc_hd__clkdlybuf4s25_1
.ends ELAD1_CONTROL

* ---- standard-cell definitions used above (copied from the PDK)
.subckt sky130_fd_sc_hd__a211oi_1 A1 A2 B1 C1 VGND VNB VPB VPWR Y
X0 VGND A2 a_139_47# VNB sky130_fd_pr__nfet_01v8 w=650000u l=150000u
X1 a_311_297# C1 Y VPB sky130_fd_pr__pfet_01v8_hvt w=1e+06u l=150000u
X2 VPWR A1 a_56_297# VPB sky130_fd_pr__pfet_01v8_hvt w=1e+06u l=150000u
X3 a_56_297# A2 VPWR VPB sky130_fd_pr__pfet_01v8_hvt w=1e+06u l=150000u
X4 a_56_297# B1 a_311_297# VPB sky130_fd_pr__pfet_01v8_hvt w=1e+06u l=150000u
X5 a_139_47# A1 Y VNB sky130_fd_pr__nfet_01v8 w=650000u l=150000u
X6 Y B1 VGND VNB sky130_fd_pr__nfet_01v8 w=650000u l=150000u
X7 VGND C1 Y VNB sky130_fd_pr__nfet_01v8 w=650000u l=150000u
.ends
.subckt sky130_fd_sc_hd__a21bo_1 A1 A2 B1_N VGND VNB VPB VPWR X
X0 VPWR a_215_297# X VPB sky130_fd_pr__pfet_01v8_hvt w=1e+06u l=150000u
X1 a_215_297# a_27_413# a_298_297# VPB sky130_fd_pr__pfet_01v8_hvt w=1e+06u l=150000u
X2 VPWR A2 a_298_297# VPB sky130_fd_pr__pfet_01v8_hvt w=1e+06u l=150000u
X3 a_298_297# A1 VPWR VPB sky130_fd_pr__pfet_01v8_hvt w=1e+06u l=150000u
X4 a_215_297# A1 a_382_47# VNB sky130_fd_pr__nfet_01v8 w=650000u l=150000u
X5 a_27_413# B1_N VGND VNB sky130_fd_pr__nfet_01v8 w=420000u l=150000u
X6 a_27_413# B1_N VPWR VPB sky130_fd_pr__pfet_01v8_hvt w=420000u l=150000u
X7 VGND a_215_297# X VNB sky130_fd_pr__nfet_01v8 w=650000u l=150000u
X8 a_382_47# A2 VGND VNB sky130_fd_pr__nfet_01v8 w=650000u l=150000u
X9 VGND a_27_413# a_215_297# VNB sky130_fd_pr__nfet_01v8 w=650000u l=150000u
.ends
.subckt sky130_fd_sc_hd__a21oi_1 A1 A2 B1 VGND VNB VPB VPWR Y
X0 a_199_47# A2 VGND VNB sky130_fd_pr__nfet_01v8 w=650000u l=150000u
X1 a_113_297# A1 VPWR VPB sky130_fd_pr__pfet_01v8_hvt w=1e+06u l=150000u
X2 Y B1 a_113_297# VPB sky130_fd_pr__pfet_01v8_hvt w=1e+06u l=150000u
X3 VGND B1 Y VNB sky130_fd_pr__nfet_01v8 w=650000u l=150000u
X4 VPWR A2 a_113_297# VPB sky130_fd_pr__pfet_01v8_hvt w=1e+06u l=150000u
X5 Y A1 a_199_47# VNB sky130_fd_pr__nfet_01v8 w=650000u l=150000u
.ends
.subckt sky130_fd_sc_hd__a22o_1 A1 A2 B1 B2 VGND VNB VPB VPWR X
X0 a_109_297# A2 VPWR VPB sky130_fd_pr__pfet_01v8_hvt w=1e+06u l=150000u
X1 VPWR A1 a_109_297# VPB sky130_fd_pr__pfet_01v8_hvt w=1e+06u l=150000u
X2 a_373_47# A2 VGND VNB sky130_fd_pr__nfet_01v8 w=650000u l=150000u
X3 a_109_47# B1 a_27_297# VNB sky130_fd_pr__nfet_01v8 w=650000u l=150000u
X4 VGND a_27_297# X VNB sky130_fd_pr__nfet_01v8 w=650000u l=150000u
X5 a_27_297# A1 a_373_47# VNB sky130_fd_pr__nfet_01v8 w=650000u l=150000u
X6 VPWR a_27_297# X VPB sky130_fd_pr__pfet_01v8_hvt w=1e+06u l=150000u
X7 VGND B2 a_109_47# VNB sky130_fd_pr__nfet_01v8 w=650000u l=150000u
X8 a_27_297# B2 a_109_297# VPB sky130_fd_pr__pfet_01v8_hvt w=1e+06u l=150000u
X9 a_109_297# B1 a_27_297# VPB sky130_fd_pr__pfet_01v8_hvt w=1e+06u l=150000u
.ends
.subckt sky130_fd_sc_hd__a31oi_1 A1 A2 A3 B1 VGND VNB VPB VPWR Y
X0 a_109_297# B1 Y VPB sky130_fd_pr__pfet_01v8_hvt w=1e+06u l=150000u
X1 a_181_47# A1 Y VNB sky130_fd_pr__nfet_01v8 w=650000u l=150000u
X2 VPWR A1 a_109_297# VPB sky130_fd_pr__pfet_01v8_hvt w=1e+06u l=150000u
X3 a_109_47# A2 a_181_47# VNB sky130_fd_pr__nfet_01v8 w=650000u l=150000u
X4 Y B1 VGND VNB sky130_fd_pr__nfet_01v8 w=650000u l=150000u
X5 VGND A3 a_109_47# VNB sky130_fd_pr__nfet_01v8 w=650000u l=150000u
X6 VPWR A3 a_109_297# VPB sky130_fd_pr__pfet_01v8_hvt w=1e+06u l=150000u
X7 a_109_297# A2 VPWR VPB sky130_fd_pr__pfet_01v8_hvt w=1e+06u l=150000u
.ends
.subckt sky130_fd_sc_hd__a32o_1 A1 A2 A3 B1 B2 VGND VNB VPB VPWR X
X0 a_93_21# B2 a_250_297# VPB sky130_fd_pr__pfet_01v8_hvt w=1e+06u l=150000u
X1 X a_93_21# VPWR VPB sky130_fd_pr__pfet_01v8_hvt w=1e+06u l=150000u
X2 a_250_297# B1 a_93_21# VPB sky130_fd_pr__pfet_01v8_hvt w=1e+06u l=150000u
X3 a_256_47# A2 a_346_47# VNB sky130_fd_pr__nfet_01v8 w=650000u l=150000u
X4 X a_93_21# VGND VNB sky130_fd_pr__nfet_01v8 w=650000u l=150000u
X5 VGND A3 a_256_47# VNB sky130_fd_pr__nfet_01v8 w=650000u l=150000u
X6 a_93_21# B1 a_584_47# VNB sky130_fd_pr__nfet_01v8 w=650000u l=150000u
X7 VPWR A1 a_250_297# VPB sky130_fd_pr__pfet_01v8_hvt w=1e+06u l=150000u
X8 a_346_47# A1 a_93_21# VNB sky130_fd_pr__nfet_01v8 w=650000u l=150000u
X9 a_250_297# A2 VPWR VPB sky130_fd_pr__pfet_01v8_hvt w=1e+06u l=150000u
X10 VPWR A3 a_250_297# VPB sky130_fd_pr__pfet_01v8_hvt w=1e+06u l=150000u
X11 a_584_47# B2 VGND VNB sky130_fd_pr__nfet_01v8 w=650000u l=150000u
.ends
.subckt sky130_fd_sc_hd__a32oi_1 A1 A2 A3 B1 B2 VGND VNB VPB VPWR Y
X0 a_27_297# A1 VPWR VPB sky130_fd_pr__pfet_01v8_hvt w=1e+06u l=150000u
X1 a_309_47# A2 a_383_47# VNB sky130_fd_pr__nfet_01v8 w=650000u l=150000u
X2 a_27_297# A3 VPWR VPB sky130_fd_pr__pfet_01v8_hvt w=1e+06u l=150000u
X3 a_109_47# B1 Y VNB sky130_fd_pr__nfet_01v8 w=650000u l=150000u
X4 VPWR A2 a_27_297# VPB sky130_fd_pr__pfet_01v8_hvt w=1e+06u l=150000u
X5 a_383_47# A3 VGND VNB sky130_fd_pr__nfet_01v8 w=650000u l=150000u
X6 Y A1 a_309_47# VNB sky130_fd_pr__nfet_01v8 w=650000u l=150000u
X7 VGND B2 a_109_47# VNB sky130_fd_pr__nfet_01v8 w=650000u l=150000u
X8 a_27_297# B2 Y VPB sky130_fd_pr__pfet_01v8_hvt w=1e+06u l=150000u
X9 Y B1 a_27_297# VPB sky130_fd_pr__pfet_01v8_hvt w=1e+06u l=150000u
.ends
.subckt sky130_fd_sc_hd__and2_0 A B VGND VNB VPB VPWR X
X0 a_40_47# B VPWR VPB sky130_fd_pr__pfet_01v8_hvt w=420000u l=150000u
X1 a_123_47# B VGND VNB sky130_fd_pr__nfet_01v8 w=420000u l=150000u
X2 a_40_47# A a_123_47# VNB sky130_fd_pr__nfet_01v8 w=420000u l=150000u
X3 VGND a_40_47# X VNB sky130_fd_pr__nfet_01v8 w=420000u l=150000u
X4 VPWR A a_40_47# VPB sky130_fd_pr__pfet_01v8_hvt w=420000u l=150000u
X5 VPWR a_40_47# X VPB sky130_fd_pr__pfet_01v8_hvt w=640000u l=150000u
.ends
.subckt sky130_fd_sc_hd__and3_1 A B C VGND VNB VPB VPWR X
X0 a_181_47# C VGND VNB sky130_fd_pr__nfet_01v8 w=420000u l=150000u
X1 a_27_47# A VPWR VPB sky130_fd_pr__pfet_01v8_hvt w=420000u l=150000u
X2 VPWR B a_27_47# VPB sky130_fd_pr__pfet_01v8_hvt w=420000u l=150000u
X3 VPWR a_27_47# X VPB sky130_fd_pr__pfet_01v8_hvt w=1e+06u l=150000u
X4 a_109_47# B a_181_47# VNB sky130_fd_pr__nfet_01v8 w=420000u l=150000u
X5 a_27_47# A a_109_47# VNB sky130_fd_pr__nfet_01v8 w=420000u l=150000u
X6 VGND a_27_47# X VNB sky130_fd_pr__nfet_01v8 w=650000u l=150000u
X7 a_27_47# C VPWR VPB sky130_fd_pr__pfet_01v8_hvt w=420000u l=150000u
.ends
.subckt sky130_fd_sc_hd__buf_1 A VGND VNB VPB VPWR X
X0 VGND a_27_47# X VNB sky130_fd_pr__nfet_01v8 w=520000u l=150000u
X1 a_27_47# A VPWR VPB sky130_fd_pr__pfet_01v8_hvt w=790000u l=150000u
X2 a_27_47# A VGND VNB sky130_fd_pr__nfet_01v8 w=520000u l=150000u
X3 VPWR a_27_47# X VPB sky130_fd_pr__pfet_01v8_hvt w=790000u l=150000u
.ends
.subckt sky130_fd_sc_hd__buf_2 A VGND VNB VPB VPWR X
X0 X a_27_47# VGND VNB sky130_fd_pr__nfet_01v8 w=650000u l=150000u
X1 a_27_47# A VPWR VPB sky130_fd_pr__pfet_01v8_hvt w=640000u l=150000u
X2 VGND a_27_47# X VNB sky130_fd_pr__nfet_01v8 w=650000u l=150000u
X3 X a_27_47# VPWR VPB sky130_fd_pr__pfet_01v8_hvt w=1e+06u l=150000u
X4 VPWR a_27_47# X VPB sky130_fd_pr__pfet_01v8_hvt w=1e+06u l=150000u
X5 a_27_47# A VGND VNB sky130_fd_pr__nfet_01v8 w=420000u l=150000u
.ends
.subckt sky130_fd_sc_hd__buf_4 A VGND VNB VPB VPWR X
X0 X a_27_47# VGND VNB sky130_fd_pr__nfet_01v8 w=650000u l=150000u
X1 VGND a_27_47# X VNB sky130_fd_pr__nfet_01v8 w=650000u l=150000u
X2 X a_27_47# VGND VNB sky130_fd_pr__nfet_01v8 w=650000u l=150000u
X3 VGND a_27_47# X VNB sky130_fd_pr__nfet_01v8 w=650000u l=150000u
X4 X a_27_47# VPWR VPB sky130_fd_pr__pfet_01v8_hvt w=1e+06u l=150000u
X5 a_27_47# A VGND VNB sky130_fd_pr__nfet_01v8 w=650000u l=150000u
X6 X a_27_47# VPWR VPB sky130_fd_pr__pfet_01v8_hvt w=1e+06u l=150000u
X7 a_27_47# A VPWR VPB sky130_fd_pr__pfet_01v8_hvt w=1e+06u l=150000u
X8 VPWR a_27_47# X VPB sky130_fd_pr__pfet_01v8_hvt w=1e+06u l=150000u
X9 VPWR a_27_47# X VPB sky130_fd_pr__pfet_01v8_hvt w=1e+06u l=150000u
.ends
.subckt sky130_fd_sc_hd__clkbuf_1 A VGND VNB VPB VPWR X
X0 VGND A a_75_212# VNB sky130_fd_pr__nfet_01v8 w=520000u l=150000u
X1 X a_75_212# VPWR VPB sky130_fd_pr__pfet_01v8_hvt w=790000u l=150000u
X2 X a_75_212# VGND VNB sky130_fd_pr__nfet_01v8 w=520000u l=150000u
X3 VPWR A a_75_212# VPB sky130_fd_pr__pfet_01v8_hvt w=790000u l=150000u
.ends
.subckt sky130_fd_sc_hd__clkbuf_16 A VGND VNB VPB VPWR X
X0 VPWR a_110_47# X VPB sky130_fd_pr__pfet_01v8_hvt w=1e+06u l=150000u
X1 X a_110_47# VGND VNB sky130_fd_pr__nfet_01v8 w=420000u l=150000u
X2 X a_110_47# VGND VNB sky130_fd_pr__nfet_01v8 w=420000u l=150000u
X3 a_110_47# A VPWR VPB sky130_fd_pr__pfet_01v8_hvt w=1e+06u l=150000u
X4 VPWR a_110_47# X VPB sky130_fd_pr__pfet_01v8_hvt w=1e+06u l=150000u
X5 X a_110_47# VPWR VPB sky130_fd_pr__pfet_01v8_hvt w=1e+06u l=150000u
X6 a_110_47# A VGND VNB sky130_fd_pr__nfet_01v8 w=420000u l=150000u
X7 VPWR A a_110_47# VPB sky130_fd_pr__pfet_01v8_hvt w=1e+06u l=150000u
X8 VGND a_110_47# X VNB sky130_fd_pr__nfet_01v8 w=420000u l=150000u
X9 VGND A a_110_47# VNB sky130_fd_pr__nfet_01v8 w=420000u l=150000u
X10 X a_110_47# VGND VNB sky130_fd_pr__nfet_01v8 w=420000u l=150000u
X11 X a_110_47# VGND VNB sky130_fd_pr__nfet_01v8 w=420000u l=150000u
X12 a_110_47# A VPWR VPB sky130_fd_pr__pfet_01v8_hvt w=1e+06u l=150000u
X13 VPWR a_110_47# X VPB sky130_fd_pr__pfet_01v8_hvt w=1e+06u l=150000u
X14 X a_110_47# VGND VNB sky130_fd_pr__nfet_01v8 w=420000u l=150000u
X15 VPWR A a_110_47# VPB sky130_fd_pr__pfet_01v8_hvt w=1e+06u l=150000u
X16 VGND a_110_47# X VNB sky130_fd_pr__nfet_01v8 w=420000u l=150000u
X17 X a_110_47# VGND VNB sky130_fd_pr__nfet_01v8 w=420000u l=150000u
X18 VGND a_110_47# X VNB sky130_fd_pr__nfet_01v8 w=420000u l=150000u
X19 VGND a_110_47# X VNB sky130_fd_pr__nfet_01v8 w=420000u l=150000u
X20 X a_110_47# VPWR VPB sky130_fd_pr__pfet_01v8_hvt w=1e+06u l=150000u
X21 X a_110_47# VPWR VPB sky130_fd_pr__pfet_01v8_hvt w=1e+06u l=150000u
X22 X a_110_47# VPWR VPB sky130_fd_pr__pfet_01v8_hvt w=1e+06u l=150000u
X23 VPWR a_110_47# X VPB sky130_fd_pr__pfet_01v8_hvt w=1e+06u l=150000u
X24 VPWR a_110_47# X VPB sky130_fd_pr__pfet_01v8_hvt w=1e+06u l=150000u
X25 VGND a_110_47# X VNB sky130_fd_pr__nfet_01v8 w=420000u l=150000u
X26 X a_110_47# VPWR VPB sky130_fd_pr__pfet_01v8_hvt w=1e+06u l=150000u
X27 X a_110_47# VGND VNB sky130_fd_pr__nfet_01v8 w=420000u l=150000u
X28 VPWR a_110_47# X VPB sky130_fd_pr__pfet_01v8_hvt w=1e+06u l=150000u
X29 VGND a_110_47# X VNB sky130_fd_pr__nfet_01v8 w=420000u l=150000u
X30 X a_110_47# VGND VNB sky130_fd_pr__nfet_01v8 w=420000u l=150000u
X31 X a_110_47# VPWR VPB sky130_fd_pr__pfet_01v8_hvt w=1e+06u l=150000u
X32 X a_110_47# VPWR VPB sky130_fd_pr__pfet_01v8_hvt w=1e+06u l=150000u
X33 X a_110_47# VPWR VPB sky130_fd_pr__pfet_01v8_hvt w=1e+06u l=150000u
X34 a_110_47# A VGND VNB sky130_fd_pr__nfet_01v8 w=420000u l=150000u
X35 VPWR a_110_47# X VPB sky130_fd_pr__pfet_01v8_hvt w=1e+06u l=150000u
X36 VGND A a_110_47# VNB sky130_fd_pr__nfet_01v8 w=420000u l=150000u
X37 VPWR a_110_47# X VPB sky130_fd_pr__pfet_01v8_hvt w=1e+06u l=150000u
X38 VGND a_110_47# X VNB sky130_fd_pr__nfet_01v8 w=420000u l=150000u
X39 VGND a_110_47# X VNB sky130_fd_pr__nfet_01v8 w=420000u l=150000u
.ends
.subckt sky130_fd_sc_hd__clkbuf_2 A VGND VNB VPB VPWR X
X0 a_27_47# A VPWR VPB sky130_fd_pr__pfet_01v8_hvt w=1e+06u l=150000u
X1 a_27_47# A VGND VNB sky130_fd_pr__nfet_01v8 w=420000u l=150000u
X2 X a_27_47# VPWR VPB sky130_fd_pr__pfet_01v8_hvt w=1e+06u l=150000u
X3 VPWR a_27_47# X VPB sky130_fd_pr__pfet_01v8_hvt w=1e+06u l=150000u
X4 X a_27_47# VGND VNB sky130_fd_pr__nfet_01v8 w=420000u l=150000u
X5 VGND a_27_47# X VNB sky130_fd_pr__nfet_01v8 w=420000u l=150000u
.ends
.subckt sky130_fd_sc_hd__clkbuf_4 A VGND VNB VPB VPWR X
X0 VPWR a_27_47# X VPB sky130_fd_pr__pfet_01v8_hvt w=1e+06u l=150000u
X1 X a_27_47# VPWR VPB sky130_fd_pr__pfet_01v8_hvt w=1e+06u l=150000u
X2 a_27_47# A VPWR VPB sky130_fd_pr__pfet_01v8_hvt w=1e+06u l=150000u
X3 a_27_47# A VGND VNB sky130_fd_pr__nfet_01v8 w=420000u l=150000u
X4 X a_27_47# VPWR VPB sky130_fd_pr__pfet_01v8_hvt w=1e+06u l=150000u
X5 VGND a_27_47# X VNB sky130_fd_pr__nfet_01v8 w=420000u l=150000u
X6 X a_27_47# VGND VNB sky130_fd_pr__nfet_01v8 w=420000u l=150000u
X7 VGND a_27_47# X VNB sky130_fd_pr__nfet_01v8 w=420000u l=150000u
X8 X a_27_47# VGND VNB sky130_fd_pr__nfet_01v8 w=420000u l=150000u
X9 VPWR a_27_47# X VPB sky130_fd_pr__pfet_01v8_hvt w=1e+06u l=150000u
.ends
.subckt sky130_fd_sc_hd__clkdlybuf4s25_1 A VGND VNB VPB VPWR X
X0 a_355_47# a_244_47# VPWR VPB sky130_fd_pr__pfet_01v8_hvt w=820000u l=250000u
X1 VPWR a_27_47# a_244_47# VPB sky130_fd_pr__pfet_01v8_hvt w=820000u l=250000u
X2 VPWR a_355_47# X VPB sky130_fd_pr__pfet_01v8_hvt w=1e+06u l=150000u
X3 a_27_47# A VPWR VPB sky130_fd_pr__pfet_01v8_hvt w=1e+06u l=150000u
X4 a_355_47# a_244_47# VGND VNB sky130_fd_pr__nfet_01v8 w=650000u l=250000u
X5 VGND a_27_47# a_244_47# VNB sky130_fd_pr__nfet_01v8 w=650000u l=250000u
X6 VGND a_355_47# X VNB sky130_fd_pr__nfet_01v8 w=420000u l=150000u
X7 a_27_47# A VGND VNB sky130_fd_pr__nfet_01v8 w=420000u l=150000u
.ends
.subckt sky130_fd_sc_hd__clkdlybuf4s50_1 A VGND VNB VPB VPWR X
X0 a_390_47# a_283_47# VGND VNB sky130_fd_pr__nfet_01v8 w=650000u l=500000u
X1 a_27_47# A VPWR VPB sky130_fd_pr__pfet_01v8_hvt w=1e+06u l=150000u
X2 VPWR a_27_47# a_283_47# VPB sky130_fd_pr__pfet_01v8_hvt w=820000u l=500000u
X3 VGND a_27_47# a_283_47# VNB sky130_fd_pr__nfet_01v8 w=650000u l=500000u
X4 VPWR a_390_47# X VPB sky130_fd_pr__pfet_01v8_hvt w=1e+06u l=150000u
X5 VGND a_390_47# X VNB sky130_fd_pr__nfet_01v8 w=420000u l=150000u
X6 a_390_47# a_283_47# VPWR VPB sky130_fd_pr__pfet_01v8_hvt w=820000u l=500000u
X7 a_27_47# A VGND VNB sky130_fd_pr__nfet_01v8 w=420000u l=150000u
.ends
.subckt sky130_fd_sc_hd__conb_1 VGND VNB VPB VPWR HI LO
XR0 VGND LO sky130_fd_pr__res_generic_po w=0.48 l=0.5
XR1 HI VPWR sky130_fd_pr__res_generic_po w=0.48 l=0.5
.ends
.subckt sky130_fd_sc_hd__decap_12 VGND VNB VPB VPWR
X0 VPWR VGND VPWR VPB sky130_fd_pr__pfet_01v8_hvt w=870000u l=4.73e+06u
X1 VGND VPWR VGND VNB sky130_fd_pr__nfet_01v8 w=550000u l=4.73e+06u
.ends
.subckt sky130_fd_sc_hd__decap_3 VGND VNB VPB VPWR
X0 VPWR VGND VPWR VPB sky130_fd_pr__pfet_01v8_hvt w=870000u l=590000u
X1 VGND VPWR VGND VNB sky130_fd_pr__nfet_01v8 w=550000u l=590000u
.ends
.subckt sky130_fd_sc_hd__decap_4 VGND VNB VPB VPWR
X0 VPWR VGND VPWR VPB sky130_fd_pr__pfet_01v8_hvt w=870000u l=1.05e+06u
X1 VGND VPWR VGND VNB sky130_fd_pr__nfet_01v8 w=550000u l=1.05e+06u
.ends
.subckt sky130_fd_sc_hd__decap_6 VGND VNB VPB VPWR
X0 VPWR VGND VPWR VPB sky130_fd_pr__pfet_01v8_hvt w=870000u l=1.97e+06u
X1 VGND VPWR VGND VNB sky130_fd_pr__nfet_01v8 w=550000u l=1.97e+06u
.ends
.subckt sky130_fd_sc_hd__decap_8 VGND VNB VPB VPWR
X0 VPWR VGND VPWR VPB sky130_fd_pr__pfet_01v8_hvt w=870000u l=2.89e+06u
X1 VGND VPWR VGND VNB sky130_fd_pr__nfet_01v8 w=550000u l=2.89e+06u
.ends
.subckt sky130_fd_sc_hd__dfrtp_1 CLK D RESET_B VGND VNB VPB VPWR Q
X0 a_1270_413# a_1283_21# VPWR VPB sky130_fd_pr__pfet_01v8_hvt w=420000u l=150000u
X1 VPWR a_543_47# a_761_289# VPB sky130_fd_pr__pfet_01v8_hvt w=840000u l=150000u
X2 VGND a_543_47# a_761_289# VNB sky130_fd_pr__nfet_01v8 w=640000u l=150000u
X3 VGND D a_448_47# VNB sky130_fd_pr__nfet_01v8 w=420000u l=150000u
X4 a_1108_47# a_193_47# a_1270_413# VPB sky130_fd_pr__pfet_01v8_hvt w=420000u l=150000u
X5 VGND a_1283_21# Q VNB sky130_fd_pr__nfet_01v8 w=650000u l=150000u
X6 a_1217_47# a_1283_21# VGND VNB sky130_fd_pr__nfet_01v8 w=420000u l=150000u
X7 a_448_47# a_27_47# a_543_47# VNB sky130_fd_pr__special_nfet_01v8 w=360000u l=150000u
X8 a_448_47# a_193_47# a_543_47# VPB sky130_fd_pr__pfet_01v8_hvt w=420000u l=150000u
X9 a_543_47# a_193_47# a_639_47# VNB sky130_fd_pr__special_nfet_01v8 w=360000u l=150000u
X10 a_1108_47# a_27_47# a_1217_47# VNB sky130_fd_pr__special_nfet_01v8 w=360000u l=150000u
X11 a_1462_47# a_1108_47# a_1283_21# VNB sky130_fd_pr__nfet_01v8 w=420000u l=150000u
X12 a_543_47# a_27_47# a_651_413# VPB sky130_fd_pr__pfet_01v8_hvt w=420000u l=150000u
X13 a_805_47# RESET_B VGND VNB sky130_fd_pr__nfet_01v8 w=420000u l=150000u
X14 a_761_289# a_193_47# a_1108_47# VNB sky130_fd_pr__special_nfet_01v8 w=360000u l=150000u
X15 VPWR RESET_B a_651_413# VPB sky130_fd_pr__pfet_01v8_hvt w=420000u l=150000u
X16 VGND a_27_47# a_193_47# VNB sky130_fd_pr__nfet_01v8 w=420000u l=150000u
X17 a_27_47# CLK VGND VNB sky130_fd_pr__nfet_01v8 w=420000u l=150000u
X18 a_27_47# CLK VPWR VPB sky130_fd_pr__pfet_01v8_hvt w=640000u l=150000u
X19 VPWR a_1283_21# Q VPB sky130_fd_pr__pfet_01v8_hvt w=1e+06u l=150000u
X20 VPWR a_27_47# a_193_47# VPB sky130_fd_pr__pfet_01v8_hvt w=640000u l=150000u
X21 a_1283_21# a_1108_47# VPWR VPB sky130_fd_pr__pfet_01v8_hvt w=420000u l=150000u
X22 VGND RESET_B a_1462_47# VNB sky130_fd_pr__nfet_01v8 w=420000u l=150000u
X23 VPWR D a_448_47# VPB sky130_fd_pr__pfet_01v8_hvt w=420000u l=150000u
X24 a_651_413# a_761_289# VPWR VPB sky130_fd_pr__pfet_01v8_hvt w=420000u l=150000u
X25 a_761_289# a_27_47# a_1108_47# VPB sky130_fd_pr__pfet_01v8_hvt w=420000u l=150000u
X26 VPWR RESET_B a_1283_21# VPB sky130_fd_pr__pfet_01v8_hvt w=420000u l=150000u
X27 a_639_47# a_761_289# a_805_47# VNB sky130_fd_pr__nfet_01v8 w=420000u l=150000u
.ends
.subckt sky130_fd_sc_hd__dfstp_1 CLK D SET_B VGND VNB VPB VPWR Q
X0 a_562_413# a_652_21# VPWR VPB sky130_fd_pr__pfet_01v8_hvt w=420000u l=150000u
X1 a_1296_47# SET_B VGND VNB sky130_fd_pr__nfet_01v8 w=420000u l=150000u
X2 a_381_47# a_193_47# a_476_47# VPB sky130_fd_pr__pfet_01v8_hvt w=420000u l=150000u
X3 a_1602_47# a_1032_413# VPWR VPB sky130_fd_pr__pfet_01v8_hvt w=640000u l=150000u
X4 a_1140_413# a_1182_261# VPWR VPB sky130_fd_pr__pfet_01v8_hvt w=420000u l=150000u
X5 a_1032_413# a_27_47# a_1224_47# VNB sky130_fd_pr__nfet_01v8 w=420000u l=150000u
X6 VGND a_1032_413# a_1182_261# VNB sky130_fd_pr__nfet_01v8 w=540000u l=150000u
X7 a_476_47# a_27_47# a_562_413# VPB sky130_fd_pr__pfet_01v8_hvt w=420000u l=150000u
X8 a_381_47# a_27_47# a_476_47# VNB sky130_fd_pr__special_nfet_01v8 w=360000u l=150000u
X9 VGND a_476_47# a_1056_47# VNB sky130_fd_pr__nfet_01v8 w=420000u l=150000u
X10 a_1602_47# a_1032_413# VGND VNB sky130_fd_pr__nfet_01v8 w=420000u l=150000u
X11 a_1056_47# a_193_47# a_1032_413# VNB sky130_fd_pr__nfet_01v8 w=420000u l=150000u
X12 VPWR SET_B a_652_21# VPB sky130_fd_pr__pfet_01v8_hvt w=420000u l=150000u
X13 a_796_47# a_476_47# a_652_21# VNB sky130_fd_pr__nfet_01v8 w=420000u l=150000u
X14 VPWR a_476_47# a_956_413# VPB sky130_fd_pr__pfet_01v8_hvt w=420000u l=150000u
X15 a_586_47# a_652_21# VGND VNB sky130_fd_pr__nfet_01v8 w=420000u l=150000u
X16 VPWR D a_381_47# VPB sky130_fd_pr__pfet_01v8_hvt w=840000u l=150000u
X17 a_652_21# a_476_47# VPWR VPB sky130_fd_pr__pfet_01v8_hvt w=420000u l=150000u
X18 a_1032_413# a_193_47# a_1140_413# VPB sky130_fd_pr__pfet_01v8_hvt w=420000u l=150000u
X19 VGND a_1602_47# Q VNB sky130_fd_pr__nfet_01v8 w=650000u l=150000u
X20 a_476_47# a_193_47# a_586_47# VNB sky130_fd_pr__special_nfet_01v8 w=360000u l=150000u
X21 a_1032_413# SET_B VPWR VPB sky130_fd_pr__pfet_01v8_hvt w=420000u l=150000u
X22 VGND a_27_47# a_193_47# VNB sky130_fd_pr__nfet_01v8 w=420000u l=150000u
X23 a_956_413# a_27_47# a_1032_413# VPB sky130_fd_pr__pfet_01v8_hvt w=420000u l=150000u
X24 a_27_47# CLK VGND VNB sky130_fd_pr__nfet_01v8 w=420000u l=150000u
X25 a_27_47# CLK VPWR VPB sky130_fd_pr__pfet_01v8_hvt w=640000u l=150000u
X26 VPWR a_1032_413# a_1182_261# VPB sky130_fd_pr__pfet_01v8_hvt w=840000u l=150000u
X27 a_1224_47# a_1182_261# a_1296_47# VNB sky130_fd_pr__nfet_01v8 w=420000u l=150000u
X28 VPWR a_27_47# a_193_47# VPB sky130_fd_pr__pfet_01v8_hvt w=640000u l=150000u
X29 VGND D a_381_47# VNB sky130_fd_pr__nfet_01v8 w=640000u l=150000u
X30 VGND SET_B a_796_47# VNB sky130_fd_pr__nfet_01v8 w=420000u l=150000u
X31 VPWR a_1602_47# Q VPB sky130_fd_pr__pfet_01v8_hvt w=1e+06u l=150000u
.ends
.subckt sky130_fd_sc_hd__dlygate4sd3_1 A VGND VNB VPB VPWR X
X0 a_391_47# a_285_47# VGND VNB sky130_fd_pr__nfet_01v8 w=420000u l=500000u
X1 VPWR a_49_47# a_285_47# VPB sky130_fd_pr__pfet_01v8_hvt w=420000u l=500000u
X2 a_49_47# A VGND VNB sky130_fd_pr__nfet_01v8 w=420000u l=150000u
X3 VPWR a_391_47# X VPB sky130_fd_pr__pfet_01v8_hvt w=1e+06u l=150000u
X4 VGND a_391_47# X VNB sky130_fd_pr__nfet_01v8 w=650000u l=150000u
X5 VGND a_49_47# a_285_47# VNB sky130_fd_pr__nfet_01v8 w=420000u l=500000u
X6 a_391_47# a_285_47# VPWR VPB sky130_fd_pr__pfet_01v8_hvt w=420000u l=500000u
X7 a_49_47# A VPWR VPB sky130_fd_pr__pfet_01v8_hvt w=420000u l=150000u
.ends
.subckt sky130_fd_sc_hd__fill_1 VGND VNB VPB VPWR
.ends
.subckt sky130_fd_sc_hd__fill_2 VGND VNB VPB VPWR
.ends
.subckt sky130_fd_sc_hd__inv_1 A VGND VNB VPB VPWR Y
X0 VGND A Y VNB sky130_fd_pr__nfet_01v8 w=650000u l=150000u
X1 VPWR A Y VPB sky130_fd_pr__pfet_01v8_hvt w=1e+06u l=150000u
.ends
.subckt sky130_fd_sc_hd__mux2_1 A0 A1 S VGND VNB VPB VPWR X
X0 VPWR S a_218_374# VPB sky130_fd_pr__pfet_01v8_hvt w=420000u l=150000u
X1 a_76_199# A0 a_439_47# VNB sky130_fd_pr__nfet_01v8 w=420000u l=150000u
X2 a_535_374# a_505_21# VPWR VPB sky130_fd_pr__pfet_01v8_hvt w=420000u l=150000u
X3 VPWR S a_505_21# VPB sky130_fd_pr__pfet_01v8_hvt w=420000u l=150000u
X4 a_76_199# A1 a_535_374# VPB sky130_fd_pr__pfet_01v8_hvt w=420000u l=150000u
X5 a_218_47# A1 a_76_199# VNB sky130_fd_pr__nfet_01v8 w=420000u l=150000u
X6 a_218_374# A0 a_76_199# VPB sky130_fd_pr__pfet_01v8_hvt w=420000u l=150000u
X7 X a_76_199# VGND VNB sky130_fd_pr__nfet_01v8 w=650000u l=150000u
X8 X a_76_199# VPWR VPB sky130_fd_pr__pfet_01v8_hvt w=1e+06u l=150000u
X9 VGND S a_218_47# VNB sky130_fd_pr__nfet_01v8 w=420000u l=150000u
X10 VGND S a_505_21# VNB sky130_fd_pr__nfet_01v8 w=420000u l=150000u
X11 a_439_47# a_505_21# VGND VNB sky130_fd_pr__nfet_01v8 w=420000u l=150000u
.ends
.subckt sky130_fd_sc_hd__mux2i_1 A0 A1 S VGND VNB VPB VPWR Y
X0 a_283_205# S VPWR VPB sky130_fd_pr__pfet_01v8_hvt w=1e+06u l=150000u
X1 VPWR S a_27_297# VPB sky130_fd_pr__pfet_01v8_hvt w=1e+06u l=150000u
X2 a_27_297# A0 Y VPB sky130_fd_pr__pfet_01v8_hvt w=1e+06u l=150000u
X3 VGND S a_193_47# VNB sky130_fd_pr__nfet_01v8 w=650000u l=150000u
X4 a_204_297# a_283_205# VPWR VPB sky130_fd_pr__pfet_01v8_hvt w=1e+06u l=150000u
X5 a_27_47# a_283_205# VGND VNB sky130_fd_pr__nfet_01v8 w=650000u l=150000u
X6 a_283_205# S VGND VNB sky130_fd_pr__nfet_01v8 w=650000u l=150000u
X7 Y A1 a_204_297# VPB sky130_fd_pr__pfet_01v8_hvt w=1e+06u l=150000u
X8 Y A1 a_193_47# VNB sky130_fd_pr__nfet_01v8 w=650000u l=150000u
X9 a_27_47# A0 Y VNB sky130_fd_pr__nfet_01v8 w=650000u l=150000u
.ends
.subckt sky130_fd_sc_hd__mux4_2 A0 A1 A2 A3 S0 S1 VGND VNB VPB VPWR X
X0 VPWR A1 a_1060_369# VPB sky130_fd_pr__pfet_01v8_hvt w=640000u l=150000u
X1 a_193_47# a_27_47# a_288_47# VNB sky130_fd_pr__special_nfet_01v8 w=360000u l=150000u
X2 VPWR a_788_316# X VPB sky130_fd_pr__pfet_01v8_hvt w=1e+06u l=150000u
X3 a_1279_413# A0 VPWR VPB sky130_fd_pr__pfet_01v8_hvt w=640000u l=150000u
X4 VGND a_788_316# X VNB sky130_fd_pr__nfet_01v8 w=650000u l=150000u
X5 X a_788_316# VPWR VPB sky130_fd_pr__pfet_01v8_hvt w=1e+06u l=150000u
X6 a_288_47# S1 a_788_316# VNB sky130_fd_pr__nfet_01v8 w=420000u l=150000u
X7 a_193_369# S0 a_288_47# VPB sky130_fd_pr__pfet_01v8_hvt w=420000u l=150000u
X8 a_372_413# A3 VPWR VPB sky130_fd_pr__pfet_01v8_hvt w=640000u l=150000u
X9 a_872_316# a_27_47# a_1281_47# VNB sky130_fd_pr__special_nfet_01v8 w=360000u l=150000u
X10 a_288_47# a_27_47# a_372_413# VPB sky130_fd_pr__pfet_01v8_hvt w=420000u l=150000u
X11 VGND A1 a_1064_47# VNB sky130_fd_pr__nfet_01v8 w=420000u l=150000u
X12 VPWR S1 a_600_345# VPB sky130_fd_pr__pfet_01v8_hvt w=640000u l=150000u
X13 a_872_316# S0 a_1279_413# VPB sky130_fd_pr__pfet_01v8_hvt w=420000u l=150000u
X14 a_27_47# S0 VPWR VPB sky130_fd_pr__pfet_01v8_hvt w=640000u l=150000u
X15 VPWR A2 a_193_369# VPB sky130_fd_pr__pfet_01v8_hvt w=640000u l=150000u
X16 VGND A2 a_193_47# VNB sky130_fd_pr__nfet_01v8 w=420000u l=150000u
X17 a_288_47# a_600_345# a_788_316# VPB sky130_fd_pr__pfet_01v8_hvt w=540000u l=150000u
X18 a_397_47# A3 VGND VNB sky130_fd_pr__nfet_01v8 w=420000u l=150000u
X19 a_27_47# S0 VGND VNB sky130_fd_pr__nfet_01v8 w=420000u l=150000u
X20 a_1060_369# a_27_47# a_872_316# VPB sky130_fd_pr__pfet_01v8_hvt w=420000u l=150000u
X21 VGND S1 a_600_345# VNB sky130_fd_pr__nfet_01v8 w=420000u l=150000u
X22 a_1281_47# A0 VGND VNB sky130_fd_pr__nfet_01v8 w=420000u l=150000u
X23 X a_788_316# VGND VNB sky130_fd_pr__nfet_01v8 w=650000u l=150000u
X24 a_288_47# S0 a_397_47# VNB sky130_fd_pr__special_nfet_01v8 w=360000u l=150000u
X25 a_788_316# S1 a_872_316# VPB sky130_fd_pr__pfet_01v8_hvt w=540000u l=150000u
X26 a_788_316# a_600_345# a_872_316# VNB sky130_fd_pr__nfet_01v8 w=420000u l=150000u
X27 a_1064_47# S0 a_872_316# VNB sky130_fd_pr__special_nfet_01v8 w=360000u l=150000u
.ends
.subckt sky130_fd_sc_hd__nand2_1 A B VGND VNB VPB VPWR Y
X0 Y A VPWR VPB sky130_fd_pr__pfet_01v8_hvt w=1e+06u l=150000u
X1 VPWR B Y VPB sky130_fd_pr__pfet_01v8_hvt w=1e+06u l=150000u
X2 VGND B a_113_47# VNB sky130_fd_pr__nfet_01v8 w=650000u l=150000u
X3 a_113_47# A Y VNB sky130_fd_pr__nfet_01v8 w=650000u l=150000u
.ends
.subckt sky130_fd_sc_hd__nand2b_1 A_N B VGND VNB VPB VPWR Y
X0 a_206_47# a_27_93# Y VNB sky130_fd_pr__nfet_01v8 w=650000u l=150000u
X1 a_27_93# A_N VGND VNB sky130_fd_pr__nfet_01v8 w=420000u l=150000u
X2 VGND B a_206_47# VNB sky130_fd_pr__nfet_01v8 w=650000u l=150000u
X3 VPWR B Y VPB sky130_fd_pr__pfet_01v8_hvt w=1e+06u l=150000u
X4 a_27_93# A_N VPWR VPB sky130_fd_pr__pfet_01v8_hvt w=420000u l=150000u
X5 Y a_27_93# VPWR VPB sky130_fd_pr__pfet_01v8_hvt w=1e+06u l=150000u
.ends
.subckt sky130_fd_sc_hd__nand3_1 A B C VGND VNB VPB VPWR Y
X0 VPWR A Y VPB sky130_fd_pr__pfet_01v8_hvt w=1e+06u l=150000u
X1 a_109_47# B a_193_47# VNB sky130_fd_pr__nfet_01v8 w=650000u l=150000u
X2 VGND C a_109_47# VNB sky130_fd_pr__nfet_01v8 w=650000u l=150000u
X3 a_193_47# A Y VNB sky130_fd_pr__nfet_01v8 w=650000u l=150000u
X4 VPWR C Y VPB sky130_fd_pr__pfet_01v8_hvt w=1e+06u l=150000u
X5 Y B VPWR VPB sky130_fd_pr__pfet_01v8_hvt w=1e+06u l=150000u
.ends
.subckt sky130_fd_sc_hd__nand3b_1 A_N B C VGND VNB VPB VPWR Y
X0 a_53_93# A_N VGND VNB sky130_fd_pr__nfet_01v8 w=420000u l=150000u
X1 a_232_47# B a_316_47# VNB sky130_fd_pr__nfet_01v8 w=650000u l=150000u
X2 a_53_93# A_N VPWR VPB sky130_fd_pr__pfet_01v8_hvt w=420000u l=150000u
X3 VPWR C Y VPB sky130_fd_pr__pfet_01v8_hvt w=1e+06u l=150000u
X4 a_316_47# a_53_93# Y VNB sky130_fd_pr__nfet_01v8 w=650000u l=150000u
X5 VPWR a_53_93# Y VPB sky130_fd_pr__pfet_01v8_hvt w=1e+06u l=150000u
X6 Y B VPWR VPB sky130_fd_pr__pfet_01v8_hvt w=1e+06u l=150000u
X7 VGND C a_232_47# VNB sky130_fd_pr__nfet_01v8 w=650000u l=150000u
.ends
.subckt sky130_fd_sc_hd__nand4_1 A B C D VGND VNB VPB VPWR Y
X0 a_277_47# A Y VNB sky130_fd_pr__nfet_01v8 w=650000u l=150000u
X1 a_193_47# B a_277_47# VNB sky130_fd_pr__nfet_01v8 w=650000u l=150000u
X2 a_109_47# C a_193_47# VNB sky130_fd_pr__nfet_01v8 w=650000u l=150000u
X3 VPWR B Y VPB sky130_fd_pr__pfet_01v8_hvt w=1e+06u l=150000u
X4 VGND D a_109_47# VNB sky130_fd_pr__nfet_01v8 w=650000u l=150000u
X5 Y A VPWR VPB sky130_fd_pr__pfet_01v8_hvt w=1e+06u l=150000u
X6 VPWR D Y VPB sky130_fd_pr__pfet_01v8_hvt w=1e+06u l=150000u
X7 Y C VPWR VPB sky130_fd_pr__pfet_01v8_hvt w=1e+06u l=150000u
.ends
.subckt sky130_fd_sc_hd__nor2_1 A B VGND VNB VPB VPWR Y
X0 a_109_297# A VPWR VPB sky130_fd_pr__pfet_01v8_hvt w=1e+06u l=150000u
X1 Y A VGND VNB sky130_fd_pr__nfet_01v8 w=650000u l=150000u
X2 VGND B Y VNB sky130_fd_pr__nfet_01v8 w=650000u l=150000u
X3 Y B a_109_297# VPB sky130_fd_pr__pfet_01v8_hvt w=1e+06u l=150000u
.ends
.subckt sky130_fd_sc_hd__nor2b_1 A B_N VGND VNB VPB VPWR Y
X0 a_74_47# B_N VPWR VPB sky130_fd_pr__pfet_01v8_hvt w=420000u l=150000u
X1 Y a_74_47# VGND VNB sky130_fd_pr__nfet_01v8 w=650000u l=150000u
X2 VGND A Y VNB sky130_fd_pr__nfet_01v8 w=650000u l=150000u
X3 a_74_47# B_N VGND VNB sky130_fd_pr__nfet_01v8 w=420000u l=150000u
X4 VPWR A a_265_297# VPB sky130_fd_pr__pfet_01v8_hvt w=1e+06u l=150000u
X5 a_265_297# a_74_47# Y VPB sky130_fd_pr__pfet_01v8_hvt w=1e+06u l=150000u
.ends
.subckt sky130_fd_sc_hd__nor3_1 A B C VGND VNB VPB VPWR Y
X0 Y A VGND VNB sky130_fd_pr__nfet_01v8 w=650000u l=150000u
X1 VGND B Y VNB sky130_fd_pr__nfet_01v8 w=650000u l=150000u
X2 a_193_297# A VPWR VPB sky130_fd_pr__pfet_01v8_hvt w=1e+06u l=150000u
X3 Y C VGND VNB sky130_fd_pr__nfet_01v8 w=650000u l=150000u
X4 Y C a_109_297# VPB sky130_fd_pr__pfet_01v8_hvt w=1e+06u l=150000u
X5 a_109_297# B a_193_297# VPB sky130_fd_pr__pfet_01v8_hvt w=1e+06u l=150000u
.ends
.subckt sky130_fd_sc_hd__nor3b_1 A B C_N VGND VNB VPB VPWR Y
X0 Y A VGND VNB sky130_fd_pr__nfet_01v8 w=650000u l=150000u
X1 VPWR C_N a_91_199# VPB sky130_fd_pr__pfet_01v8_hvt w=420000u l=150000u
X2 a_161_297# B a_245_297# VPB sky130_fd_pr__pfet_01v8_hvt w=1e+06u l=150000u
X3 VGND C_N a_91_199# VNB sky130_fd_pr__nfet_01v8 w=420000u l=150000u
X4 Y a_91_199# a_161_297# VPB sky130_fd_pr__pfet_01v8_hvt w=1e+06u l=150000u
X5 a_245_297# A VPWR VPB sky130_fd_pr__pfet_01v8_hvt w=1e+06u l=150000u
X6 VGND B Y VNB sky130_fd_pr__nfet_01v8 w=650000u l=150000u
X7 Y a_91_199# VGND VNB sky130_fd_pr__nfet_01v8 w=650000u l=150000u
.ends
.subckt sky130_fd_sc_hd__nor4_1 A B C D VGND VNB VPB VPWR Y
X0 VGND B Y VNB sky130_fd_pr__nfet_01v8 w=650000u l=150000u
X1 a_191_297# B a_297_297# VPB sky130_fd_pr__pfet_01v8_hvt w=1e+06u l=150000u
X2 a_297_297# A VPWR VPB sky130_fd_pr__pfet_01v8_hvt w=1e+06u l=150000u
X3 Y C VGND VNB sky130_fd_pr__nfet_01v8 w=650000u l=150000u
X4 VGND D Y VNB sky130_fd_pr__nfet_01v8 w=650000u l=150000u
X5 a_109_297# C a_191_297# VPB sky130_fd_pr__pfet_01v8_hvt w=1e+06u l=150000u
X6 Y D a_109_297# VPB sky130_fd_pr__pfet_01v8_hvt w=1e+06u l=150000u
X7 Y A VGND VNB sky130_fd_pr__nfet_01v8 w=650000u l=150000u
.ends
.subckt sky130_fd_sc_hd__nor4b_1 A B C D_N VGND VNB VPB VPWR Y
X0 VPWR D_N a_91_199# VPB sky130_fd_pr__pfet_01v8_hvt w=420000u l=150000u
X1 VGND D_N a_91_199# VNB sky130_fd_pr__nfet_01v8 w=420000u l=150000u
X2 a_161_297# C a_245_297# VPB sky130_fd_pr__pfet_01v8_hvt w=1e+06u l=150000u
X3 a_245_297# B a_341_297# VPB sky130_fd_pr__pfet_01v8_hvt w=1e+06u l=150000u
X4 Y a_91_199# a_161_297# VPB sky130_fd_pr__pfet_01v8_hvt w=1e+06u l=150000u
X5 VGND B Y VNB sky130_fd_pr__nfet_01v8 w=650000u l=150000u
X6 Y C VGND VNB sky130_fd_pr__nfet_01v8 w=650000u l=150000u
X7 a_341_297# A VPWR VPB sky130_fd_pr__pfet_01v8_hvt w=1e+06u l=150000u
X8 VGND a_91_199# Y VNB sky130_fd_pr__nfet_01v8 w=650000u l=150000u
X9 Y A VGND VNB sky130_fd_pr__nfet_01v8 w=650000u l=150000u
.ends
.subckt sky130_fd_sc_hd__o211ai_1 A1 A2 B1 C1 VGND VNB VPB VPWR Y
X0 a_110_297# A2 Y VPB sky130_fd_pr__pfet_01v8_hvt w=1e+06u l=150000u
X1 VPWR A1 a_110_297# VPB sky130_fd_pr__pfet_01v8_hvt w=1e+06u l=150000u
X2 a_27_47# A1 VGND VNB sky130_fd_pr__nfet_01v8 w=650000u l=150000u
X3 a_326_47# C1 Y VNB sky130_fd_pr__nfet_01v8 w=650000u l=150000u
X4 VPWR C1 Y VPB sky130_fd_pr__pfet_01v8_hvt w=1e+06u l=150000u
X5 VGND A2 a_27_47# VNB sky130_fd_pr__nfet_01v8 w=650000u l=150000u
X6 a_27_47# B1 a_326_47# VNB sky130_fd_pr__nfet_01v8 w=650000u l=150000u
X7 Y B1 VPWR VPB sky130_fd_pr__pfet_01v8_hvt w=1e+06u l=150000u
.ends
.subckt sky130_fd_sc_hd__o21ai_0 A1 A2 B1 VGND VNB VPB VPWR Y
X0 VGND A2 a_32_47# VNB sky130_fd_pr__nfet_01v8 w=420000u l=150000u
X1 Y B1 VPWR VPB sky130_fd_pr__pfet_01v8_hvt w=640000u l=150000u
X2 a_32_47# B1 Y VNB sky130_fd_pr__nfet_01v8 w=420000u l=150000u
X3 a_32_47# A1 VGND VNB sky130_fd_pr__nfet_01v8 w=420000u l=150000u
X4 VPWR A1 a_120_369# VPB sky130_fd_pr__pfet_01v8_hvt w=640000u l=150000u
X5 a_120_369# A2 Y VPB sky130_fd_pr__pfet_01v8_hvt w=640000u l=150000u
.ends
.subckt sky130_fd_sc_hd__o21ai_1 A1 A2 B1 VGND VNB VPB VPWR Y
X0 a_109_297# A2 Y VPB sky130_fd_pr__pfet_01v8_hvt w=1e+06u l=150000u
X1 Y B1 VPWR VPB sky130_fd_pr__pfet_01v8_hvt w=700000u l=150000u
X2 a_27_47# A1 VGND VNB sky130_fd_pr__nfet_01v8 w=650000u l=150000u
X3 a_27_47# B1 Y VNB sky130_fd_pr__nfet_01v8 w=650000u l=150000u
X4 VPWR A1 a_109_297# VPB sky130_fd_pr__pfet_01v8_hvt w=1e+06u l=150000u
X5 VGND A2 a_27_47# VNB sky130_fd_pr__nfet_01v8 w=650000u l=150000u
.ends
.subckt sky130_fd_sc_hd__o31ai_1 A1 A2 A3 B1 VGND VNB VPB VPWR Y
X0 Y B1 VPWR VPB sky130_fd_pr__pfet_01v8_hvt w=1e+06u l=150000u
X1 VGND A3 a_109_47# VNB sky130_fd_pr__nfet_01v8 w=650000u l=150000u
X2 a_109_47# A2 VGND VNB sky130_fd_pr__nfet_01v8 w=650000u l=150000u
X3 a_109_47# B1 Y VNB sky130_fd_pr__nfet_01v8 w=650000u l=150000u
X4 a_193_297# A3 Y VPB sky130_fd_pr__pfet_01v8_hvt w=1e+06u l=150000u
X5 VGND A1 a_109_47# VNB sky130_fd_pr__nfet_01v8 w=650000u l=150000u
X6 VPWR A1 a_109_297# VPB sky130_fd_pr__pfet_01v8_hvt w=1e+06u l=150000u
X7 a_109_297# A2 a_193_297# VPB sky130_fd_pr__pfet_01v8_hvt w=1e+06u l=150000u
.ends
.subckt sky130_fd_sc_hd__o41ai_1 A1 A2 A3 A4 B1 VGND VNB VPB VPWR Y
X0 a_432_297# A1 VPWR VPB sky130_fd_pr__pfet_01v8_hvt w=1e+06u l=150000u
X1 a_109_47# A2 VGND VNB sky130_fd_pr__nfet_01v8 w=650000u l=150000u
X2 VGND A3 a_109_47# VNB sky130_fd_pr__nfet_01v8 w=650000u l=150000u
X3 a_109_47# A4 VGND VNB sky130_fd_pr__nfet_01v8 w=650000u l=150000u
X4 a_193_297# A3 a_348_297# VPB sky130_fd_pr__pfet_01v8_hvt w=1e+06u l=150000u
X5 Y B1 a_109_47# VNB sky130_fd_pr__nfet_01v8 w=650000u l=150000u
X6 VGND A1 a_109_47# VNB sky130_fd_pr__nfet_01v8 w=650000u l=150000u
X7 VPWR B1 Y VPB sky130_fd_pr__pfet_01v8_hvt w=1e+06u l=150000u
X8 Y A4 a_193_297# VPB sky130_fd_pr__pfet_01v8_hvt w=1e+06u l=150000u
X9 a_348_297# A2 a_432_297# VPB sky130_fd_pr__pfet_01v8_hvt w=1e+06u l=150000u
.ends
.subckt sky130_fd_sc_hd__or3_1 A B C VGND VNB VPB VPWR X
X0 VPWR a_29_53# X VPB sky130_fd_pr__pfet_01v8_hvt w=1e+06u l=150000u
X1 a_111_297# B a_183_297# VPB sky130_fd_pr__pfet_01v8_hvt w=420000u l=150000u
X2 a_29_53# C a_111_297# VPB sky130_fd_pr__pfet_01v8_hvt w=420000u l=150000u
X3 VGND a_29_53# X VNB sky130_fd_pr__nfet_01v8 w=650000u l=150000u
X4 a_29_53# C VGND VNB sky130_fd_pr__nfet_01v8 w=420000u l=150000u
X5 a_29_53# A VGND VNB sky130_fd_pr__nfet_01v8 w=420000u l=150000u
X6 a_183_297# A VPWR VPB sky130_fd_pr__pfet_01v8_hvt w=420000u l=150000u
X7 VGND B a_29_53# VNB sky130_fd_pr__nfet_01v8 w=420000u l=150000u
.ends
.subckt sky130_fd_sc_hd__tapvpwrvgnd_1 VGND VPWR
.ends
.subckt sky130_fd_sc_hd__xor2_1 A B VGND VNB VPB VPWR X
X0 a_35_297# A VGND VNB sky130_fd_pr__nfet_01v8 w=650000u l=150000u
X1 VGND B a_35_297# VNB sky130_fd_pr__nfet_01v8 w=650000u l=150000u
X2 X a_35_297# VGND VNB sky130_fd_pr__nfet_01v8 w=650000u l=150000u
X3 a_285_297# B VPWR VPB sky130_fd_pr__pfet_01v8_hvt w=1e+06u l=150000u
X4 VPWR A a_285_297# VPB sky130_fd_pr__pfet_01v8_hvt w=1e+06u l=150000u
X5 a_35_297# B a_117_297# VPB sky130_fd_pr__pfet_01v8_hvt w=1e+06u l=150000u
X6 a_117_297# A VPWR VPB sky130_fd_pr__pfet_01v8_hvt w=1e+06u l=150000u
X7 a_285_47# B X VNB sky130_fd_pr__nfet_01v8 w=650000u l=150000u
X8 a_285_297# a_35_297# X VPB sky130_fd_pr__pfet_01v8_hvt w=1e+06u l=150000u
X9 VGND A a_285_47# VNB sky130_fd_pr__nfet_01v8 w=650000u l=150000u
.ends
