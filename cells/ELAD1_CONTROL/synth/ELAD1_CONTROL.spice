* ELAD1_CONTROL: generated by gl2spice.py from elad1_control.nl.v (module elad1_control)
* 165 standard cells, 37 cell types

.subckt ELAD1_CONTROL clk rst_n ena ui_in[7] ui_in[6] ui_in[5] ui_in[4] ui_in[3] ui_in[2] ui_in[1] ui_in[0] en_mg en_mc en_pg en_pc en_n clr_mg clr_mc clr_pg clr_pc clr_n hen agg_clk status[7] status[6] status[5] status[4] status[3] status[2] status[1] status[0] VDPWR VGND
X116 clr_n VGND VGND VDPWR VDPWR _103_ sky130_fd_sc_hd__clkinv_1
X117 state[0] status[0] VGND VGND VDPWR VDPWR status[1] sky130_fd_sc_hd__nor2_1
X118 state[0] status[0] apply_s[1] VGND VGND VDPWR VDPWR _104_ sky130_fd_sc_hd__o21ai_0
X119 apply_s[2] _104_ VGND VGND VDPWR VDPWR _105_ sky130_fd_sc_hd__nor2_1
X120 apply_s[2] _104_ VGND VGND VDPWR VDPWR _106_ sky130_fd_sc_hd__or2_0
X121 cnt[1] cnt[3] cnt[2] cnt[0] VGND VGND VDPWR VDPWR _107_ sky130_fd_sc_hd__nor4b_1
X122 cnt[1] cnt[3] cnt[2] cnt[0] VGND VGND VDPWR VDPWR _108_ sky130_fd_sc_hd__or4b_1
X123 state[2] _108_ VGND VGND VDPWR VDPWR _109_ sky130_fd_sc_hd__nand2_1
X124 state[2] _106_ _108_ VGND VGND VDPWR VDPWR _110_ sky130_fd_sc_hd__nand3_1
X125 cnt[1] cnt[0] VGND VGND VDPWR VDPWR _111_ sky130_fd_sc_hd__nand2_1
X126 cnt[3] cnt[2] cnt[1] cnt[0] VGND VGND VDPWR VDPWR _112_ sky130_fd_sc_hd__nand4bb_1
X127 state[3] _106_ VGND VGND VDPWR VDPWR _113_ sky130_fd_sc_hd__nand2_1
X128 _112_ _113_ _110_ VGND VGND VDPWR VDPWR _008_ sky130_fd_sc_hd__o21ai_0
X129 status[0] state[5] _106_ VGND VGND VDPWR VDPWR _114_ sky130_fd_sc_hd__o21ai_0
X130 cfg[2] ui_in[2] VGND VGND VDPWR VDPWR _035_ sky130_fd_sc_hd__xor2_1
X131 ui_in[5] cfg[5] VGND VGND VDPWR VDPWR _036_ sky130_fd_sc_hd__xor2_1
X132 cfg[1] ui_in[1] VGND VGND VDPWR VDPWR _037_ sky130_fd_sc_hd__xor2_1
X133 _035_ _036_ _037_ VGND VGND VDPWR VDPWR _038_ sky130_fd_sc_hd__nor3_1
X134 cfg[0] ui_in[0] VGND VGND VDPWR VDPWR _039_ sky130_fd_sc_hd__xor2_1
X135 cfg[3] ui_in[3] VGND VGND VDPWR VDPWR _040_ sky130_fd_sc_hd__xor2_1
X136 a_req ui_in[4] VGND VGND VDPWR VDPWR _041_ sky130_fd_sc_hd__xor2_1
X137 ui_in[6] cfg[6] VGND VGND VDPWR VDPWR _042_ sky130_fd_sc_hd__xor2_1
X138 _039_ _040_ _041_ _042_ VGND VGND VDPWR VDPWR _043_ sky130_fd_sc_hd__nor4_1
X139 _038_ _043_ VGND VGND VDPWR VDPWR _044_ sky130_fd_sc_hd__nand2_1
X140 state[2] _106_ _107_ _044_ VGND VGND VDPWR VDPWR _045_ sky130_fd_sc_hd__nand4_1
X141 _114_ _045_ VGND VGND VDPWR VDPWR _007_ sky130_fd_sc_hd__nand2_1
X142 state[4] _106_ _107_ VGND VGND VDPWR VDPWR _046_ sky130_fd_sc_hd__nand3_1
X143 state[3] _112_ VGND VGND VDPWR VDPWR _047_ sky130_fd_sc_hd__nand2_1
X144 _105_ _047_ _046_ VGND VGND VDPWR VDPWR _009_ sky130_fd_sc_hd__o21ai_0
X145 state[4] _108_ VGND VGND VDPWR VDPWR _048_ sky130_fd_sc_hd__nand2_1
X146 _106_ _048_ VGND VGND VDPWR VDPWR _010_ sky130_fd_sc_hd__nand2_1
X147 status[0] cfg[0] VGND VGND VDPWR VDPWR status[2] sky130_fd_sc_hd__and2_0
X148 status[0] cfg[1] VGND VGND VDPWR VDPWR status[3] sky130_fd_sc_hd__and2_0
X149 div[0] status[6] VGND VGND VDPWR VDPWR _001_ sky130_fd_sc_hd__nor2b_1
X150 div[0] div[1] status[6] VGND VGND VDPWR VDPWR _049_ sky130_fd_sc_hd__o21ai_0
X151 div[0] div[1] _049_ VGND VGND VDPWR VDPWR _002_ sky130_fd_sc_hd__a21oi_1
X152 div[0] div[1] div[2] VGND VGND VDPWR VDPWR _050_ sky130_fd_sc_hd__nand3_1
X153 div[0] div[1] div[2] VGND VGND VDPWR VDPWR _051_ sky130_fd_sc_hd__a21oi_1
X154 status[6] _050_ VGND VGND VDPWR VDPWR _052_ sky130_fd_sc_hd__nand2_1
X155 _051_ _052_ VGND VGND VDPWR VDPWR _003_ sky130_fd_sc_hd__nor2_1
X156 div[3] _050_ VGND VGND VDPWR VDPWR _053_ sky130_fd_sc_hd__xnor2_1
X157 status[6] _053_ VGND VGND VDPWR VDPWR _004_ sky130_fd_sc_hd__and2_0
X158 ena rst_n VGND VGND VDPWR VDPWR arst_n sky130_fd_sc_hd__and2_0
X159 status[0] cfg[2] VGND VGND VDPWR VDPWR status[4] sky130_fd_sc_hd__and2_0
X160 div[0] div[1] div[2] div[3] cfg[5] cfg[6] VGND VGND VDPWR VDPWR _054_ sky130_fd_sc_hd__mux4_2
X161 status[6] _054_ VGND VGND VDPWR VDPWR _000_ sky130_fd_sc_hd__and2_0
X162 state[0] _106_ VGND VGND VDPWR VDPWR _005_ sky130_fd_sc_hd__and2_0
X163 state[2] _107_ VGND VGND VDPWR VDPWR _055_ sky130_fd_sc_hd__and2_0
X164 state[2] _107_ VGND VGND VDPWR VDPWR _056_ sky130_fd_sc_hd__nand2_1
X165 _106_ _038_ _043_ _055_ VGND VGND VDPWR VDPWR _057_ sky130_fd_sc_hd__nand4_1
X166 _057_ VGND VGND VDPWR VDPWR _006_ sky130_fd_sc_hd__clkinv_1
X167 status[0] _105_ VGND VGND VDPWR VDPWR _058_ sky130_fd_sc_hd__nor2_1
X168 status[0] _106_ VGND VGND VDPWR VDPWR _059_ sky130_fd_sc_hd__and2_0
X169 cfg[1] cfg[0] VGND VGND VDPWR VDPWR _060_ sky130_fd_sc_hd__nand2_1
X170 cfg[1] cfg[0] a_req VGND VGND VDPWR VDPWR _061_ sky130_fd_sc_hd__and3_1
X171 status[6] _058_ _059_ _061_ VGND VGND VDPWR VDPWR _011_ sky130_fd_sc_hd__a22o_1
X172 state[5] state[4] _106_ _048_ VGND VGND VDPWR VDPWR _062_ sky130_fd_sc_hd__o211ai_1
X173 en_mg _062_ VGND VGND VDPWR VDPWR _063_ sky130_fd_sc_hd__nand2_1
X174 cfg[1] cfg[0] VGND VGND VDPWR VDPWR _064_ sky130_fd_sc_hd__nand2b_1
X175 cfg[2] _064_ VGND VGND VDPWR VDPWR _065_ sky130_fd_sc_hd__nor2_1
X176 state[5] _065_ VGND VGND VDPWR VDPWR _066_ sky130_fd_sc_hd__nand2_1
X177 _062_ _066_ _063_ VGND VGND VDPWR VDPWR _012_ sky130_fd_sc_hd__o21ai_0
X178 en_mc _062_ VGND VGND VDPWR VDPWR _067_ sky130_fd_sc_hd__nand2_1
X179 cfg[1] cfg[0] cfg[2] state[5] VGND VGND VDPWR VDPWR _068_ sky130_fd_sc_hd__nand4b_1
X180 _062_ _068_ _067_ VGND VGND VDPWR VDPWR _013_ sky130_fd_sc_hd__o21ai_0
X181 en_pg _062_ VGND VGND VDPWR VDPWR _069_ sky130_fd_sc_hd__nand2_1
X182 cfg[0] cfg[1] VGND VGND VDPWR VDPWR _070_ sky130_fd_sc_hd__nand2b_1
X183 cfg[2] _070_ VGND VGND VDPWR VDPWR _071_ sky130_fd_sc_hd__nor2_1
X184 state[5] _071_ VGND VGND VDPWR VDPWR _072_ sky130_fd_sc_hd__nand2_1
X185 _062_ _072_ _069_ VGND VGND VDPWR VDPWR _014_ sky130_fd_sc_hd__o21ai_0
X186 en_pc _062_ VGND VGND VDPWR VDPWR _073_ sky130_fd_sc_hd__nand2_1
X187 cfg[0] cfg[2] state[5] cfg[1] VGND VGND VDPWR VDPWR _074_ sky130_fd_sc_hd__nand4b_1
X188 _062_ _074_ _073_ VGND VGND VDPWR VDPWR _015_ sky130_fd_sc_hd__o21ai_0
X189 en_n _062_ VGND VGND VDPWR VDPWR _075_ sky130_fd_sc_hd__nand2_1
X190 cfg[1] cfg[0] state[5] VGND VGND VDPWR VDPWR _076_ sky130_fd_sc_hd__nand3_1
X191 _062_ _076_ _075_ VGND VGND VDPWR VDPWR _016_ sky130_fd_sc_hd__o21ai_0
X192 state[2] state[3] _106_ _109_ _047_ VGND VGND VDPWR VDPWR _077_ sky130_fd_sc_hd__o2111a_1
X193 _044_ _056_ _077_ VGND VGND VDPWR VDPWR _078_ sky130_fd_sc_hd__o21a_1
X194 state[2] _065_ _077_ VGND VGND VDPWR VDPWR _079_ sky130_fd_sc_hd__nand3b_1
X195 clr_mg _078_ _079_ VGND VGND VDPWR VDPWR _017_ sky130_fd_sc_hd__o21a_1
X196 _064_ state[2] cfg[2] VGND VGND VDPWR VDPWR _080_ sky130_fd_sc_hd__or3b_1
X197 clr_mc _080_ _078_ VGND VGND VDPWR VDPWR _018_ sky130_fd_sc_hd__mux2_1
X198 state[2] _071_ _077_ VGND VGND VDPWR VDPWR _081_ sky130_fd_sc_hd__nand3b_1
X199 clr_pg _078_ _081_ VGND VGND VDPWR VDPWR _019_ sky130_fd_sc_hd__o21a_1
X200 _070_ state[2] cfg[2] VGND VGND VDPWR VDPWR _082_ sky130_fd_sc_hd__or3b_1
X201 clr_pc _082_ _078_ VGND VGND VDPWR VDPWR _020_ sky130_fd_sc_hd__mux2_1
X202 state[2] _060_ VGND VGND VDPWR VDPWR _083_ sky130_fd_sc_hd__nor2_1
X203 _103_ _083_ _078_ VGND VGND VDPWR VDPWR _021_ sky130_fd_sc_hd__mux2i_1
X204 _064_ _070_ VGND VGND VDPWR VDPWR _084_ sky130_fd_sc_hd__nand2_1
X205 cfg[3] _059_ _084_ hen _058_ VGND VGND VDPWR VDPWR _022_ sky130_fd_sc_hd__a32o_1
X206 state[2] state[3] state[4] VGND VGND VDPWR VDPWR _085_ sky130_fd_sc_hd__nor3_1
X207 _106_ _085_ VGND VGND VDPWR VDPWR _086_ sky130_fd_sc_hd__nand2_1
X208 _105_ _085_ VGND VGND VDPWR VDPWR _087_ sky130_fd_sc_hd__nor2_1
X209 cnt[0] _087_ VGND VGND VDPWR VDPWR _088_ sky130_fd_sc_hd__nor2_1
X210 cnt[0] _086_ _088_ VGND VGND VDPWR VDPWR _023_ sky130_fd_sc_hd__a21oi_1
X211 cnt[0] _086_ cnt[1] VGND VGND VDPWR VDPWR _089_ sky130_fd_sc_hd__a21oi_1
X212 state[2] state[4] _107_ VGND VGND VDPWR VDPWR _090_ sky130_fd_sc_hd__o21ai_0
X213 _106_ _111_ _090_ VGND VGND VDPWR VDPWR _091_ sky130_fd_sc_hd__nand3_1
X214 _086_ _091_ _089_ VGND VGND VDPWR VDPWR _024_ sky130_fd_sc_hd__a21oi_1
X215 cnt[1] cnt[0] _086_ cnt[2] VGND VGND VDPWR VDPWR _092_ sky130_fd_sc_hd__a31oi_1
X216 cnt[1] cnt[0] cnt[2] VGND VGND VDPWR VDPWR _093_ sky130_fd_sc_hd__nand3_1
X217 state[2] state[4] _112_ _093_ _106_ VGND VGND VDPWR VDPWR _094_ sky130_fd_sc_hd__o311ai_0
X218 _086_ _094_ _092_ VGND VGND VDPWR VDPWR _025_ sky130_fd_sc_hd__a21oi_1
X219 _106_ _085_ _093_ VGND VGND VDPWR VDPWR _095_ sky130_fd_sc_hd__a21oi_1
X220 cnt[3] _095_ _106_ VGND VGND VDPWR VDPWR _096_ sky130_fd_sc_hd__o21ai_0
X221 cnt[3] _095_ _096_ VGND VGND VDPWR VDPWR _026_ sky130_fd_sc_hd__a21oi_1
X222 state[2] _107_ _044_ _105_ VGND VGND VDPWR VDPWR _097_ sky130_fd_sc_hd__a31oi_1
X223 ui_in[0] _105_ _097_ cfg[0] VGND VGND VDPWR VDPWR _027_ sky130_fd_sc_hd__a22o_1
X224 ui_in[1] _105_ _097_ cfg[1] VGND VGND VDPWR VDPWR _028_ sky130_fd_sc_hd__a22o_1
X225 ui_in[2] _105_ _097_ cfg[2] VGND VGND VDPWR VDPWR _029_ sky130_fd_sc_hd__a22o_1
X226 ui_in[3] _105_ _097_ cfg[3] VGND VGND VDPWR VDPWR _030_ sky130_fd_sc_hd__a22o_1
X227 ui_in[4] _105_ _097_ a_req VGND VGND VDPWR VDPWR _031_ sky130_fd_sc_hd__a22o_1
X228 ui_in[5] _105_ _097_ cfg[5] VGND VGND VDPWR VDPWR _032_ sky130_fd_sc_hd__a22o_1
X229 ui_in[6] _105_ _097_ cfg[6] VGND VGND VDPWR VDPWR _033_ sky130_fd_sc_hd__a22o_1
X230 status[0] state[2] _105_ VGND VGND VDPWR VDPWR _098_ sky130_fd_sc_hd__or3_1
X231 cfg[3] _064_ _070_ VGND VGND VDPWR VDPWR _099_ sky130_fd_sc_hd__nand3_1
X232 a_req _060_ VGND VGND VDPWR VDPWR _100_ sky130_fd_sc_hd__nand2_1
X233 status[0] _106_ _099_ _100_ VGND VGND VDPWR VDPWR _101_ sky130_fd_sc_hd__nand4_1
X234 _110_ _057_ _098_ _101_ VGND VGND VDPWR VDPWR _102_ sky130_fd_sc_hd__nand4_1
X235 _106_ status[7] _102_ VGND VGND VDPWR VDPWR _034_ sky130_fd_sc_hd__mux2_1
X236 clk _011_ rstn_i VGND VGND VDPWR VDPWR status[6] sky130_fd_sc_hd__dfrtp_1
X237 clk _005_ rstn_i VGND VGND VDPWR VDPWR state[0] sky130_fd_sc_hd__dfstp_2
X238 clk _007_ rstn_i VGND VGND VDPWR VDPWR status[0] sky130_fd_sc_hd__dfrtp_1
X239 clk _008_ rstn_i VGND VGND VDPWR VDPWR state[2] sky130_fd_sc_hd__dfrtp_1
X240 clk _009_ rstn_i VGND VGND VDPWR VDPWR state[3] sky130_fd_sc_hd__dfrtp_1
X241 clk _010_ rstn_i VGND VGND VDPWR VDPWR state[4] sky130_fd_sc_hd__dfrtp_1
X242 clk _006_ rstn_i VGND VGND VDPWR VDPWR state[5] sky130_fd_sc_hd__dfrtp_1
X243 clk _000_ rstn_i VGND VGND VDPWR VDPWR agg_clk sky130_fd_sc_hd__dfrtp_1
X244 clk _001_ rstn_i VGND VGND VDPWR VDPWR div[0] sky130_fd_sc_hd__dfrtp_1
X245 clk _002_ rstn_i VGND VGND VDPWR VDPWR div[1] sky130_fd_sc_hd__dfrtp_1
X246 clk _003_ rstn_i VGND VGND VDPWR VDPWR div[2] sky130_fd_sc_hd__dfrtp_1
X247 clk _004_ rstn_i VGND VGND VDPWR VDPWR div[3] sky130_fd_sc_hd__dfrtp_1
X248 clk _012_ rstn_i VGND VGND VDPWR VDPWR en_mg sky130_fd_sc_hd__dfrtp_1
X249 clk _013_ rstn_i VGND VGND VDPWR VDPWR en_mc sky130_fd_sc_hd__dfrtp_1
X250 clk _014_ rstn_i VGND VGND VDPWR VDPWR en_pg sky130_fd_sc_hd__dfrtp_1
X251 clk _015_ rstn_i VGND VGND VDPWR VDPWR en_pc sky130_fd_sc_hd__dfrtp_1
X252 clk _016_ rstn_i VGND VGND VDPWR VDPWR en_n sky130_fd_sc_hd__dfrtp_1
X253 clk _017_ rstn_i VGND VGND VDPWR VDPWR clr_mg sky130_fd_sc_hd__dfstp_2
X254 clk _018_ rstn_i VGND VGND VDPWR VDPWR clr_mc sky130_fd_sc_hd__dfstp_2
X255 clk _019_ rstn_i VGND VGND VDPWR VDPWR clr_pg sky130_fd_sc_hd__dfstp_2
X256 clk _020_ rstn_i VGND VGND VDPWR VDPWR clr_pc sky130_fd_sc_hd__dfstp_2
X257 clk _021_ rstn_i VGND VGND VDPWR VDPWR clr_n sky130_fd_sc_hd__dfstp_2
X258 clk _022_ rstn_i VGND VGND VDPWR VDPWR hen sky130_fd_sc_hd__dfrtp_1
X259 clk _023_ rstn_i VGND VGND VDPWR VDPWR cnt[0] sky130_fd_sc_hd__dfrtp_1
X260 clk _024_ rstn_i VGND VGND VDPWR VDPWR cnt[1] sky130_fd_sc_hd__dfrtp_1
X261 clk _025_ rstn_i VGND VGND VDPWR VDPWR cnt[2] sky130_fd_sc_hd__dfrtp_1
X262 clk _026_ rstn_i VGND VGND VDPWR VDPWR cnt[3] sky130_fd_sc_hd__dfrtp_1
X263 clk _027_ rstn_i VGND VGND VDPWR VDPWR cfg[0] sky130_fd_sc_hd__dfrtp_1
X264 clk _028_ rstn_i VGND VGND VDPWR VDPWR cfg[1] sky130_fd_sc_hd__dfrtp_1
X265 clk _029_ rstn_i VGND VGND VDPWR VDPWR cfg[2] sky130_fd_sc_hd__dfrtp_1
X266 clk _030_ rstn_i VGND VGND VDPWR VDPWR cfg[3] sky130_fd_sc_hd__dfrtp_1
X267 clk _031_ rstn_i VGND VGND VDPWR VDPWR a_req sky130_fd_sc_hd__dfrtp_1
X268 clk _032_ rstn_i VGND VGND VDPWR VDPWR cfg[5] sky130_fd_sc_hd__dfrtp_1
X269 clk _033_ rstn_i VGND VGND VDPWR VDPWR cfg[6] sky130_fd_sc_hd__dfrtp_1
X270 clk _034_ rstn_i VGND VGND VDPWR VDPWR status[7] sky130_fd_sc_hd__dfrtp_1
X271 clk ui_in[7] rstn_i VGND VGND VDPWR VDPWR apply_s[0] sky130_fd_sc_hd__dfrtp_1
X272 clk apply_s[0] rstn_i VGND VGND VDPWR VDPWR apply_s[1] sky130_fd_sc_hd__dfrtp_1
X273 clk apply_s[1] rstn_i VGND VGND VDPWR VDPWR apply_s[2] sky130_fd_sc_hd__dfrtp_1
X274 clk _115_ arst_n VGND VGND VDPWR VDPWR rsync[0] sky130_fd_sc_hd__dfrtp_1
X275 clk rsync[0] arst_n VGND VGND VDPWR VDPWR rstn_i sky130_fd_sc_hd__dfrtp_1
X276 VGND VGND VDPWR VDPWR _115_ nc_276_LO sky130_fd_sc_hd__conb_1
X277 a_req VGND VGND VDPWR VDPWR cfg[4] sky130_fd_sc_hd__buf_2
X278 rstn_i VGND VGND VDPWR VDPWR rsync[1] sky130_fd_sc_hd__buf_2
X279 status[0] VGND VGND VDPWR VDPWR state[1] sky130_fd_sc_hd__buf_2
X280 hen VGND VGND VDPWR VDPWR status[5] sky130_fd_sc_hd__buf_2
.ends ELAD1_CONTROL

* ---- sky130_fd_sc_hd cell definitions used above (copied from sky130_fd_sc_hd.spice)
.subckt sky130_fd_sc_hd__a21oi_1 A1 A2 B1 VGND VNB VPB VPWR Y
X0 a_199_47# A2 VGND VNB sky130_fd_pr__nfet_01v8 w=650000u l=150000u
X1 a_113_297# A1 VPWR VPB sky130_fd_pr__pfet_01v8_hvt w=1e+06u l=150000u
X2 Y B1 a_113_297# VPB sky130_fd_pr__pfet_01v8_hvt w=1e+06u l=150000u
X3 VGND B1 Y VNB sky130_fd_pr__nfet_01v8 w=650000u l=150000u
X4 VPWR A2 a_113_297# VPB sky130_fd_pr__pfet_01v8_hvt w=1e+06u l=150000u
X5 Y A1 a_199_47# VNB sky130_fd_pr__nfet_01v8 w=650000u l=150000u
.ends
.subckt sky130_fd_sc_hd__a22o_1 A1 A2 B1 B2 VGND VNB VPB VPWR X
X0 a_109_297# A2 VPWR VPB sky130_fd_pr__pfet_01v8_hvt w=1e+06u l=150000u
X1 VPWR A1 a_109_297# VPB sky130_fd_pr__pfet_01v8_hvt w=1e+06u l=150000u
X2 a_373_47# A2 VGND VNB sky130_fd_pr__nfet_01v8 w=650000u l=150000u
X3 a_109_47# B1 a_27_297# VNB sky130_fd_pr__nfet_01v8 w=650000u l=150000u
X4 VGND a_27_297# X VNB sky130_fd_pr__nfet_01v8 w=650000u l=150000u
X5 a_27_297# A1 a_373_47# VNB sky130_fd_pr__nfet_01v8 w=650000u l=150000u
X6 VPWR a_27_297# X VPB sky130_fd_pr__pfet_01v8_hvt w=1e+06u l=150000u
X7 VGND B2 a_109_47# VNB sky130_fd_pr__nfet_01v8 w=650000u l=150000u
X8 a_27_297# B2 a_109_297# VPB sky130_fd_pr__pfet_01v8_hvt w=1e+06u l=150000u
X9 a_109_297# B1 a_27_297# VPB sky130_fd_pr__pfet_01v8_hvt w=1e+06u l=150000u
.ends
.subckt sky130_fd_sc_hd__a31oi_1 A1 A2 A3 B1 VGND VNB VPB VPWR Y
X0 a_109_297# B1 Y VPB sky130_fd_pr__pfet_01v8_hvt w=1e+06u l=150000u
X1 a_181_47# A1 Y VNB sky130_fd_pr__nfet_01v8 w=650000u l=150000u
X2 VPWR A1 a_109_297# VPB sky130_fd_pr__pfet_01v8_hvt w=1e+06u l=150000u
X3 a_109_47# A2 a_181_47# VNB sky130_fd_pr__nfet_01v8 w=650000u l=150000u
X4 Y B1 VGND VNB sky130_fd_pr__nfet_01v8 w=650000u l=150000u
X5 VGND A3 a_109_47# VNB sky130_fd_pr__nfet_01v8 w=650000u l=150000u
X6 VPWR A3 a_109_297# VPB sky130_fd_pr__pfet_01v8_hvt w=1e+06u l=150000u
X7 a_109_297# A2 VPWR VPB sky130_fd_pr__pfet_01v8_hvt w=1e+06u l=150000u
.ends
.subckt sky130_fd_sc_hd__a32o_1 A1 A2 A3 B1 B2 VGND VNB VPB VPWR X
X0 a_93_21# B2 a_250_297# VPB sky130_fd_pr__pfet_01v8_hvt w=1e+06u l=150000u
X1 X a_93_21# VPWR VPB sky130_fd_pr__pfet_01v8_hvt w=1e+06u l=150000u
X2 a_250_297# B1 a_93_21# VPB sky130_fd_pr__pfet_01v8_hvt w=1e+06u l=150000u
X3 a_256_47# A2 a_346_47# VNB sky130_fd_pr__nfet_01v8 w=650000u l=150000u
X4 X a_93_21# VGND VNB sky130_fd_pr__nfet_01v8 w=650000u l=150000u
X5 VGND A3 a_256_47# VNB sky130_fd_pr__nfet_01v8 w=650000u l=150000u
X6 a_93_21# B1 a_584_47# VNB sky130_fd_pr__nfet_01v8 w=650000u l=150000u
X7 VPWR A1 a_250_297# VPB sky130_fd_pr__pfet_01v8_hvt w=1e+06u l=150000u
X8 a_346_47# A1 a_93_21# VNB sky130_fd_pr__nfet_01v8 w=650000u l=150000u
X9 a_250_297# A2 VPWR VPB sky130_fd_pr__pfet_01v8_hvt w=1e+06u l=150000u
X10 VPWR A3 a_250_297# VPB sky130_fd_pr__pfet_01v8_hvt w=1e+06u l=150000u
X11 a_584_47# B2 VGND VNB sky130_fd_pr__nfet_01v8 w=650000u l=150000u
.ends
.subckt sky130_fd_sc_hd__and2_0 A B VGND VNB VPB VPWR X
X0 a_40_47# B VPWR VPB sky130_fd_pr__pfet_01v8_hvt w=420000u l=150000u
X1 a_123_47# B VGND VNB sky130_fd_pr__nfet_01v8 w=420000u l=150000u
X2 a_40_47# A a_123_47# VNB sky130_fd_pr__nfet_01v8 w=420000u l=150000u
X3 VGND a_40_47# X VNB sky130_fd_pr__nfet_01v8 w=420000u l=150000u
X4 VPWR A a_40_47# VPB sky130_fd_pr__pfet_01v8_hvt w=420000u l=150000u
X5 VPWR a_40_47# X VPB sky130_fd_pr__pfet_01v8_hvt w=640000u l=150000u
.ends
.subckt sky130_fd_sc_hd__and3_1 A B C VGND VNB VPB VPWR X
X0 a_181_47# C VGND VNB sky130_fd_pr__nfet_01v8 w=420000u l=150000u
X1 a_27_47# A VPWR VPB sky130_fd_pr__pfet_01v8_hvt w=420000u l=150000u
X2 VPWR B a_27_47# VPB sky130_fd_pr__pfet_01v8_hvt w=420000u l=150000u
X3 VPWR a_27_47# X VPB sky130_fd_pr__pfet_01v8_hvt w=1e+06u l=150000u
X4 a_109_47# B a_181_47# VNB sky130_fd_pr__nfet_01v8 w=420000u l=150000u
X5 a_27_47# A a_109_47# VNB sky130_fd_pr__nfet_01v8 w=420000u l=150000u
X6 VGND a_27_47# X VNB sky130_fd_pr__nfet_01v8 w=650000u l=150000u
X7 a_27_47# C VPWR VPB sky130_fd_pr__pfet_01v8_hvt w=420000u l=150000u
.ends
.subckt sky130_fd_sc_hd__buf_2 A VGND VNB VPB VPWR X
X0 X a_27_47# VGND VNB sky130_fd_pr__nfet_01v8 w=650000u l=150000u
X1 a_27_47# A VPWR VPB sky130_fd_pr__pfet_01v8_hvt w=640000u l=150000u
X2 VGND a_27_47# X VNB sky130_fd_pr__nfet_01v8 w=650000u l=150000u
X3 X a_27_47# VPWR VPB sky130_fd_pr__pfet_01v8_hvt w=1e+06u l=150000u
X4 VPWR a_27_47# X VPB sky130_fd_pr__pfet_01v8_hvt w=1e+06u l=150000u
X5 a_27_47# A VGND VNB sky130_fd_pr__nfet_01v8 w=420000u l=150000u
.ends
.subckt sky130_fd_sc_hd__clkinv_1 A VGND VNB VPB VPWR Y
X0 Y A VPWR VPB sky130_fd_pr__pfet_01v8_hvt w=840000u l=150000u
X1 Y A VGND VNB sky130_fd_pr__nfet_01v8 w=420000u l=150000u
X2 VPWR A Y VPB sky130_fd_pr__pfet_01v8_hvt w=840000u l=150000u
.ends
.subckt sky130_fd_sc_hd__conb_1 VGND VNB VPB VPWR HI LO
XR0 VGND LO sky130_fd_pr__res_generic_po w=480000u l=45000u
XR1 HI VPWR sky130_fd_pr__res_generic_po w=480000u l=45000u
.ends
.subckt sky130_fd_sc_hd__dfrtp_1 CLK D RESET_B VGND VNB VPB VPWR Q
X0 a_1270_413# a_1283_21# VPWR VPB sky130_fd_pr__pfet_01v8_hvt w=420000u l=150000u
X1 VPWR a_543_47# a_761_289# VPB sky130_fd_pr__pfet_01v8_hvt w=840000u l=150000u
X2 VGND a_543_47# a_761_289# VNB sky130_fd_pr__nfet_01v8 w=640000u l=150000u
X3 VGND D a_448_47# VNB sky130_fd_pr__nfet_01v8 w=420000u l=150000u
X4 a_1108_47# a_193_47# a_1270_413# VPB sky130_fd_pr__pfet_01v8_hvt w=420000u l=150000u
X5 VGND a_1283_21# Q VNB sky130_fd_pr__nfet_01v8 w=650000u l=150000u
X6 a_1217_47# a_1283_21# VGND VNB sky130_fd_pr__nfet_01v8 w=420000u l=150000u
X7 a_448_47# a_27_47# a_543_47# VNB sky130_fd_pr__special_nfet_01v8 w=360000u l=150000u
X8 a_448_47# a_193_47# a_543_47# VPB sky130_fd_pr__pfet_01v8_hvt w=420000u l=150000u
X9 a_543_47# a_193_47# a_639_47# VNB sky130_fd_pr__special_nfet_01v8 w=360000u l=150000u
X10 a_1108_47# a_27_47# a_1217_47# VNB sky130_fd_pr__special_nfet_01v8 w=360000u l=150000u
X11 a_1462_47# a_1108_47# a_1283_21# VNB sky130_fd_pr__nfet_01v8 w=420000u l=150000u
X12 a_543_47# a_27_47# a_651_413# VPB sky130_fd_pr__pfet_01v8_hvt w=420000u l=150000u
X13 a_805_47# RESET_B VGND VNB sky130_fd_pr__nfet_01v8 w=420000u l=150000u
X14 a_761_289# a_193_47# a_1108_47# VNB sky130_fd_pr__special_nfet_01v8 w=360000u l=150000u
X15 VPWR RESET_B a_651_413# VPB sky130_fd_pr__pfet_01v8_hvt w=420000u l=150000u
X16 VGND a_27_47# a_193_47# VNB sky130_fd_pr__nfet_01v8 w=420000u l=150000u
X17 a_27_47# CLK VGND VNB sky130_fd_pr__nfet_01v8 w=420000u l=150000u
X18 a_27_47# CLK VPWR VPB sky130_fd_pr__pfet_01v8_hvt w=640000u l=150000u
X19 VPWR a_1283_21# Q VPB sky130_fd_pr__pfet_01v8_hvt w=1e+06u l=150000u
X20 VPWR a_27_47# a_193_47# VPB sky130_fd_pr__pfet_01v8_hvt w=640000u l=150000u
X21 a_1283_21# a_1108_47# VPWR VPB sky130_fd_pr__pfet_01v8_hvt w=420000u l=150000u
X22 VGND RESET_B a_1462_47# VNB sky130_fd_pr__nfet_01v8 w=420000u l=150000u
X23 VPWR D a_448_47# VPB sky130_fd_pr__pfet_01v8_hvt w=420000u l=150000u
X24 a_651_413# a_761_289# VPWR VPB sky130_fd_pr__pfet_01v8_hvt w=420000u l=150000u
X25 a_761_289# a_27_47# a_1108_47# VPB sky130_fd_pr__pfet_01v8_hvt w=420000u l=150000u
X26 VPWR RESET_B a_1283_21# VPB sky130_fd_pr__pfet_01v8_hvt w=420000u l=150000u
X27 a_639_47# a_761_289# a_805_47# VNB sky130_fd_pr__nfet_01v8 w=420000u l=150000u
.ends
.subckt sky130_fd_sc_hd__dfstp_2 CLK D SET_B VGND VNB VPB VPWR Q
X0 a_562_413# a_652_21# VPWR VPB sky130_fd_pr__pfet_01v8_hvt w=420000u l=150000u
X1 a_956_413# a_27_47# a_1028_413# VPB sky130_fd_pr__pfet_01v8_hvt w=420000u l=150000u
X2 a_1300_47# SET_B VGND VNB sky130_fd_pr__nfet_01v8 w=420000u l=150000u
X3 a_381_47# a_193_47# a_476_47# VPB sky130_fd_pr__pfet_01v8_hvt w=420000u l=150000u
X4 VGND a_1602_47# Q VNB sky130_fd_pr__nfet_01v8 w=650000u l=150000u
X5 a_1028_413# a_193_47# a_1136_413# VPB sky130_fd_pr__pfet_01v8_hvt w=420000u l=150000u
X6 VPWR a_1602_47# Q VPB sky130_fd_pr__pfet_01v8_hvt w=1e+06u l=150000u
X7 VGND a_1028_413# a_1178_261# VNB sky130_fd_pr__nfet_01v8 w=540000u l=150000u
X8 a_476_47# a_27_47# a_562_413# VPB sky130_fd_pr__pfet_01v8_hvt w=420000u l=150000u
X9 a_381_47# a_27_47# a_476_47# VNB sky130_fd_pr__special_nfet_01v8 w=360000u l=150000u
X10 VGND a_476_47# a_1056_47# VNB sky130_fd_pr__nfet_01v8 w=420000u l=150000u
X11 a_1028_413# SET_B VPWR VPB sky130_fd_pr__pfet_01v8_hvt w=420000u l=150000u
X12 a_1602_47# a_1028_413# VPWR VPB sky130_fd_pr__pfet_01v8_hvt w=1e+06u l=150000u
X13 a_1602_47# a_1028_413# VGND VNB sky130_fd_pr__nfet_01v8 w=650000u l=150000u
X14 Q a_1602_47# VPWR VPB sky130_fd_pr__pfet_01v8_hvt w=1e+06u l=150000u
X15 a_1056_47# a_193_47# a_1028_413# VNB sky130_fd_pr__nfet_01v8 w=420000u l=150000u
X16 a_1228_47# a_1178_261# a_1300_47# VNB sky130_fd_pr__nfet_01v8 w=420000u l=150000u
X17 VPWR SET_B a_652_21# VPB sky130_fd_pr__pfet_01v8_hvt w=420000u l=150000u
X18 a_796_47# a_476_47# a_652_21# VNB sky130_fd_pr__nfet_01v8 w=420000u l=150000u
X19 VPWR a_476_47# a_956_413# VPB sky130_fd_pr__pfet_01v8_hvt w=420000u l=150000u
X20 VPWR a_1028_413# a_1178_261# VPB sky130_fd_pr__pfet_01v8_hvt w=840000u l=150000u
X21 a_586_47# a_652_21# VGND VNB sky130_fd_pr__nfet_01v8 w=420000u l=150000u
X22 VPWR D a_381_47# VPB sky130_fd_pr__pfet_01v8_hvt w=840000u l=150000u
X23 a_652_21# a_476_47# VPWR VPB sky130_fd_pr__pfet_01v8_hvt w=420000u l=150000u
X24 a_1136_413# a_1178_261# VPWR VPB sky130_fd_pr__pfet_01v8_hvt w=420000u l=150000u
X25 a_476_47# a_193_47# a_586_47# VNB sky130_fd_pr__special_nfet_01v8 w=360000u l=150000u
X26 VGND a_27_47# a_193_47# VNB sky130_fd_pr__nfet_01v8 w=420000u l=150000u
X27 a_27_47# CLK VGND VNB sky130_fd_pr__nfet_01v8 w=420000u l=150000u
X28 a_27_47# CLK VPWR VPB sky130_fd_pr__pfet_01v8_hvt w=640000u l=150000u
X29 Q a_1602_47# VGND VNB sky130_fd_pr__nfet_01v8 w=650000u l=150000u
X30 VPWR a_27_47# a_193_47# VPB sky130_fd_pr__pfet_01v8_hvt w=640000u l=150000u
X31 VGND D a_381_47# VNB sky130_fd_pr__nfet_01v8 w=640000u l=150000u
X32 VGND SET_B a_796_47# VNB sky130_fd_pr__nfet_01v8 w=420000u l=150000u
X33 a_1028_413# a_27_47# a_1228_47# VNB sky130_fd_pr__nfet_01v8 w=420000u l=150000u
.ends
.subckt sky130_fd_sc_hd__mux2_1 A0 A1 S VGND VNB VPB VPWR X
X0 VPWR S a_218_374# VPB sky130_fd_pr__pfet_01v8_hvt w=420000u l=150000u
X1 a_76_199# A0 a_439_47# VNB sky130_fd_pr__nfet_01v8 w=420000u l=150000u
X2 a_535_374# a_505_21# VPWR VPB sky130_fd_pr__pfet_01v8_hvt w=420000u l=150000u
X3 VPWR S a_505_21# VPB sky130_fd_pr__pfet_01v8_hvt w=420000u l=150000u
X4 a_76_199# A1 a_535_374# VPB sky130_fd_pr__pfet_01v8_hvt w=420000u l=150000u
X5 a_218_47# A1 a_76_199# VNB sky130_fd_pr__nfet_01v8 w=420000u l=150000u
X6 a_218_374# A0 a_76_199# VPB sky130_fd_pr__pfet_01v8_hvt w=420000u l=150000u
X7 X a_76_199# VGND VNB sky130_fd_pr__nfet_01v8 w=650000u l=150000u
X8 X a_76_199# VPWR VPB sky130_fd_pr__pfet_01v8_hvt w=1e+06u l=150000u
X9 VGND S a_218_47# VNB sky130_fd_pr__nfet_01v8 w=420000u l=150000u
X10 VGND S a_505_21# VNB sky130_fd_pr__nfet_01v8 w=420000u l=150000u
X11 a_439_47# a_505_21# VGND VNB sky130_fd_pr__nfet_01v8 w=420000u l=150000u
.ends
.subckt sky130_fd_sc_hd__mux2i_1 A0 A1 S VGND VNB VPB VPWR Y
X0 a_283_205# S VPWR VPB sky130_fd_pr__pfet_01v8_hvt w=1e+06u l=150000u
X1 VPWR S a_27_297# VPB sky130_fd_pr__pfet_01v8_hvt w=1e+06u l=150000u
X2 a_27_297# A0 Y VPB sky130_fd_pr__pfet_01v8_hvt w=1e+06u l=150000u
X3 VGND S a_193_47# VNB sky130_fd_pr__nfet_01v8 w=650000u l=150000u
X4 a_204_297# a_283_205# VPWR VPB sky130_fd_pr__pfet_01v8_hvt w=1e+06u l=150000u
X5 a_27_47# a_283_205# VGND VNB sky130_fd_pr__nfet_01v8 w=650000u l=150000u
X6 a_283_205# S VGND VNB sky130_fd_pr__nfet_01v8 w=650000u l=150000u
X7 Y A1 a_204_297# VPB sky130_fd_pr__pfet_01v8_hvt w=1e+06u l=150000u
X8 Y A1 a_193_47# VNB sky130_fd_pr__nfet_01v8 w=650000u l=150000u
X9 a_27_47# A0 Y VNB sky130_fd_pr__nfet_01v8 w=650000u l=150000u
.ends
.subckt sky130_fd_sc_hd__mux4_2 A0 A1 A2 A3 S0 S1 VGND VNB VPB VPWR X
X0 VPWR A1 a_1060_369# VPB sky130_fd_pr__pfet_01v8_hvt w=640000u l=150000u
X1 a_193_47# a_27_47# a_288_47# VNB sky130_fd_pr__special_nfet_01v8 w=360000u l=150000u
X2 VPWR a_788_316# X VPB sky130_fd_pr__pfet_01v8_hvt w=1e+06u l=150000u
X3 a_1279_413# A0 VPWR VPB sky130_fd_pr__pfet_01v8_hvt w=640000u l=150000u
X4 VGND a_788_316# X VNB sky130_fd_pr__nfet_01v8 w=650000u l=150000u
X5 X a_788_316# VPWR VPB sky130_fd_pr__pfet_01v8_hvt w=1e+06u l=150000u
X6 a_288_47# S1 a_788_316# VNB sky130_fd_pr__nfet_01v8 w=420000u l=150000u
X7 a_193_369# S0 a_288_47# VPB sky130_fd_pr__pfet_01v8_hvt w=420000u l=150000u
X8 a_372_413# A3 VPWR VPB sky130_fd_pr__pfet_01v8_hvt w=640000u l=150000u
X9 a_872_316# a_27_47# a_1281_47# VNB sky130_fd_pr__special_nfet_01v8 w=360000u l=150000u
X10 a_288_47# a_27_47# a_372_413# VPB sky130_fd_pr__pfet_01v8_hvt w=420000u l=150000u
X11 VGND A1 a_1064_47# VNB sky130_fd_pr__nfet_01v8 w=420000u l=150000u
X12 VPWR S1 a_600_345# VPB sky130_fd_pr__pfet_01v8_hvt w=640000u l=150000u
X13 a_872_316# S0 a_1279_413# VPB sky130_fd_pr__pfet_01v8_hvt w=420000u l=150000u
X14 a_27_47# S0 VPWR VPB sky130_fd_pr__pfet_01v8_hvt w=640000u l=150000u
X15 VPWR A2 a_193_369# VPB sky130_fd_pr__pfet_01v8_hvt w=640000u l=150000u
X16 VGND A2 a_193_47# VNB sky130_fd_pr__nfet_01v8 w=420000u l=150000u
X17 a_288_47# a_600_345# a_788_316# VPB sky130_fd_pr__pfet_01v8_hvt w=540000u l=150000u
X18 a_397_47# A3 VGND VNB sky130_fd_pr__nfet_01v8 w=420000u l=150000u
X19 a_27_47# S0 VGND VNB sky130_fd_pr__nfet_01v8 w=420000u l=150000u
X20 a_1060_369# a_27_47# a_872_316# VPB sky130_fd_pr__pfet_01v8_hvt w=420000u l=150000u
X21 VGND S1 a_600_345# VNB sky130_fd_pr__nfet_01v8 w=420000u l=150000u
X22 a_1281_47# A0 VGND VNB sky130_fd_pr__nfet_01v8 w=420000u l=150000u
X23 X a_788_316# VGND VNB sky130_fd_pr__nfet_01v8 w=650000u l=150000u
X24 a_288_47# S0 a_397_47# VNB sky130_fd_pr__special_nfet_01v8 w=360000u l=150000u
X25 a_788_316# S1 a_872_316# VPB sky130_fd_pr__pfet_01v8_hvt w=540000u l=150000u
X26 a_788_316# a_600_345# a_872_316# VNB sky130_fd_pr__nfet_01v8 w=420000u l=150000u
X27 a_1064_47# S0 a_872_316# VNB sky130_fd_pr__special_nfet_01v8 w=360000u l=150000u
.ends
.subckt sky130_fd_sc_hd__nand2_1 A B VGND VNB VPB VPWR Y
X0 Y A VPWR VPB sky130_fd_pr__pfet_01v8_hvt w=1e+06u l=150000u
X1 VPWR B Y VPB sky130_fd_pr__pfet_01v8_hvt w=1e+06u l=150000u
X2 VGND B a_113_47# VNB sky130_fd_pr__nfet_01v8 w=650000u l=150000u
X3 a_113_47# A Y VNB sky130_fd_pr__nfet_01v8 w=650000u l=150000u
.ends
.subckt sky130_fd_sc_hd__nand2b_1 A_N B VGND VNB VPB VPWR Y
X0 a_206_47# a_27_93# Y VNB sky130_fd_pr__nfet_01v8 w=650000u l=150000u
X1 a_27_93# A_N VGND VNB sky130_fd_pr__nfet_01v8 w=420000u l=150000u
X2 VGND B a_206_47# VNB sky130_fd_pr__nfet_01v8 w=650000u l=150000u
X3 VPWR B Y VPB sky130_fd_pr__pfet_01v8_hvt w=1e+06u l=150000u
X4 a_27_93# A_N VPWR VPB sky130_fd_pr__pfet_01v8_hvt w=420000u l=150000u
X5 Y a_27_93# VPWR VPB sky130_fd_pr__pfet_01v8_hvt w=1e+06u l=150000u
.ends
.subckt sky130_fd_sc_hd__nand3_1 A B C VGND VNB VPB VPWR Y
X0 VPWR A Y VPB sky130_fd_pr__pfet_01v8_hvt w=1e+06u l=150000u
X1 a_109_47# B a_193_47# VNB sky130_fd_pr__nfet_01v8 w=650000u l=150000u
X2 VGND C a_109_47# VNB sky130_fd_pr__nfet_01v8 w=650000u l=150000u
X3 a_193_47# A Y VNB sky130_fd_pr__nfet_01v8 w=650000u l=150000u
X4 VPWR C Y VPB sky130_fd_pr__pfet_01v8_hvt w=1e+06u l=150000u
X5 Y B VPWR VPB sky130_fd_pr__pfet_01v8_hvt w=1e+06u l=150000u
.ends
.subckt sky130_fd_sc_hd__nand3b_1 A_N B C VGND VNB VPB VPWR Y
X0 a_53_93# A_N VGND VNB sky130_fd_pr__nfet_01v8 w=420000u l=150000u
X1 a_232_47# B a_316_47# VNB sky130_fd_pr__nfet_01v8 w=650000u l=150000u
X2 a_53_93# A_N VPWR VPB sky130_fd_pr__pfet_01v8_hvt w=420000u l=150000u
X3 VPWR C Y VPB sky130_fd_pr__pfet_01v8_hvt w=1e+06u l=150000u
X4 a_316_47# a_53_93# Y VNB sky130_fd_pr__nfet_01v8 w=650000u l=150000u
X5 VPWR a_53_93# Y VPB sky130_fd_pr__pfet_01v8_hvt w=1e+06u l=150000u
X6 Y B VPWR VPB sky130_fd_pr__pfet_01v8_hvt w=1e+06u l=150000u
X7 VGND C a_232_47# VNB sky130_fd_pr__nfet_01v8 w=650000u l=150000u
.ends
.subckt sky130_fd_sc_hd__nand4_1 A B C D VGND VNB VPB VPWR Y
X0 a_277_47# A Y VNB sky130_fd_pr__nfet_01v8 w=650000u l=150000u
X1 a_193_47# B a_277_47# VNB sky130_fd_pr__nfet_01v8 w=650000u l=150000u
X2 a_109_47# C a_193_47# VNB sky130_fd_pr__nfet_01v8 w=650000u l=150000u
X3 VPWR B Y VPB sky130_fd_pr__pfet_01v8_hvt w=1e+06u l=150000u
X4 VGND D a_109_47# VNB sky130_fd_pr__nfet_01v8 w=650000u l=150000u
X5 Y A VPWR VPB sky130_fd_pr__pfet_01v8_hvt w=1e+06u l=150000u
X6 VPWR D Y VPB sky130_fd_pr__pfet_01v8_hvt w=1e+06u l=150000u
X7 Y C VPWR VPB sky130_fd_pr__pfet_01v8_hvt w=1e+06u l=150000u
.ends
.subckt sky130_fd_sc_hd__nand4b_1 A_N B C D VGND VNB VPB VPWR Y
X0 Y a_41_93# VPWR VPB sky130_fd_pr__pfet_01v8_hvt w=1e+06u l=150000u
X1 a_232_47# C a_316_47# VNB sky130_fd_pr__nfet_01v8 w=650000u l=150000u
X2 a_423_47# a_41_93# Y VNB sky130_fd_pr__nfet_01v8 w=650000u l=150000u
X3 a_41_93# A_N VPWR VPB sky130_fd_pr__pfet_01v8_hvt w=420000u l=150000u
X4 VPWR D Y VPB sky130_fd_pr__pfet_01v8_hvt w=1e+06u l=150000u
X5 a_316_47# B a_423_47# VNB sky130_fd_pr__nfet_01v8 w=650000u l=150000u
X6 a_41_93# A_N VGND VNB sky130_fd_pr__nfet_01v8 w=420000u l=150000u
X7 VPWR B Y VPB sky130_fd_pr__pfet_01v8_hvt w=1e+06u l=150000u
X8 Y C VPWR VPB sky130_fd_pr__pfet_01v8_hvt w=1e+06u l=150000u
X9 VGND D a_232_47# VNB sky130_fd_pr__nfet_01v8 w=650000u l=150000u
.ends
.subckt sky130_fd_sc_hd__nand4bb_1 A_N B_N C D VGND VNB VPB VPWR Y
X0 Y a_496_21# VPWR VPB sky130_fd_pr__pfet_01v8_hvt w=1e+06u l=150000u
X1 a_426_47# a_496_21# Y VNB sky130_fd_pr__nfet_01v8 w=650000u l=150000u
X2 VPWR A_N a_496_21# VPB sky130_fd_pr__pfet_01v8_hvt w=420000u l=150000u
X3 VGND A_N a_496_21# VNB sky130_fd_pr__nfet_01v8 w=420000u l=150000u
X4 a_27_93# B_N VGND VNB sky130_fd_pr__nfet_01v8 w=420000u l=150000u
X5 Y C VPWR VPB sky130_fd_pr__pfet_01v8_hvt w=1e+06u l=150000u
X6 a_326_47# a_27_93# a_426_47# VNB sky130_fd_pr__nfet_01v8 w=650000u l=150000u
X7 a_27_93# B_N VPWR VPB sky130_fd_pr__pfet_01v8_hvt w=420000u l=150000u
X8 VPWR D Y VPB sky130_fd_pr__pfet_01v8_hvt w=1e+06u l=150000u
X9 VPWR a_27_93# Y VPB sky130_fd_pr__pfet_01v8_hvt w=1e+06u l=150000u
X10 VGND D a_218_47# VNB sky130_fd_pr__nfet_01v8 w=650000u l=150000u
X11 a_218_47# C a_326_47# VNB sky130_fd_pr__nfet_01v8 w=650000u l=150000u
.ends
.subckt sky130_fd_sc_hd__nor2_1 A B VGND VNB VPB VPWR Y
X0 a_109_297# A VPWR VPB sky130_fd_pr__pfet_01v8_hvt w=1e+06u l=150000u
X1 Y A VGND VNB sky130_fd_pr__nfet_01v8 w=650000u l=150000u
X2 VGND B Y VNB sky130_fd_pr__nfet_01v8 w=650000u l=150000u
X3 Y B a_109_297# VPB sky130_fd_pr__pfet_01v8_hvt w=1e+06u l=150000u
.ends
.subckt sky130_fd_sc_hd__nor2b_1 A B_N VGND VNB VPB VPWR Y
X0 a_74_47# B_N VPWR VPB sky130_fd_pr__pfet_01v8_hvt w=420000u l=150000u
X1 Y a_74_47# VGND VNB sky130_fd_pr__nfet_01v8 w=650000u l=150000u
X2 VGND A Y VNB sky130_fd_pr__nfet_01v8 w=650000u l=150000u
X3 a_74_47# B_N VGND VNB sky130_fd_pr__nfet_01v8 w=420000u l=150000u
X4 VPWR A a_265_297# VPB sky130_fd_pr__pfet_01v8_hvt w=1e+06u l=150000u
X5 a_265_297# a_74_47# Y VPB sky130_fd_pr__pfet_01v8_hvt w=1e+06u l=150000u
.ends
.subckt sky130_fd_sc_hd__nor3_1 A B C VGND VNB VPB VPWR Y
X0 Y A VGND VNB sky130_fd_pr__nfet_01v8 w=650000u l=150000u
X1 VGND B Y VNB sky130_fd_pr__nfet_01v8 w=650000u l=150000u
X2 a_193_297# A VPWR VPB sky130_fd_pr__pfet_01v8_hvt w=1e+06u l=150000u
X3 Y C VGND VNB sky130_fd_pr__nfet_01v8 w=650000u l=150000u
X4 Y C a_109_297# VPB sky130_fd_pr__pfet_01v8_hvt w=1e+06u l=150000u
X5 a_109_297# B a_193_297# VPB sky130_fd_pr__pfet_01v8_hvt w=1e+06u l=150000u
.ends
.subckt sky130_fd_sc_hd__nor4_1 A B C D VGND VNB VPB VPWR Y
X0 VGND B Y VNB sky130_fd_pr__nfet_01v8 w=650000u l=150000u
X1 a_191_297# B a_297_297# VPB sky130_fd_pr__pfet_01v8_hvt w=1e+06u l=150000u
X2 a_297_297# A VPWR VPB sky130_fd_pr__pfet_01v8_hvt w=1e+06u l=150000u
X3 Y C VGND VNB sky130_fd_pr__nfet_01v8 w=650000u l=150000u
X4 VGND D Y VNB sky130_fd_pr__nfet_01v8 w=650000u l=150000u
X5 a_109_297# C a_191_297# VPB sky130_fd_pr__pfet_01v8_hvt w=1e+06u l=150000u
X6 Y D a_109_297# VPB sky130_fd_pr__pfet_01v8_hvt w=1e+06u l=150000u
X7 Y A VGND VNB sky130_fd_pr__nfet_01v8 w=650000u l=150000u
.ends
.subckt sky130_fd_sc_hd__nor4b_1 A B C D_N VGND VNB VPB VPWR Y
X0 VPWR D_N a_91_199# VPB sky130_fd_pr__pfet_01v8_hvt w=420000u l=150000u
X1 VGND D_N a_91_199# VNB sky130_fd_pr__nfet_01v8 w=420000u l=150000u
X2 a_161_297# C a_245_297# VPB sky130_fd_pr__pfet_01v8_hvt w=1e+06u l=150000u
X3 a_245_297# B a_341_297# VPB sky130_fd_pr__pfet_01v8_hvt w=1e+06u l=150000u
X4 Y a_91_199# a_161_297# VPB sky130_fd_pr__pfet_01v8_hvt w=1e+06u l=150000u
X5 VGND B Y VNB sky130_fd_pr__nfet_01v8 w=650000u l=150000u
X6 Y C VGND VNB sky130_fd_pr__nfet_01v8 w=650000u l=150000u
X7 a_341_297# A VPWR VPB sky130_fd_pr__pfet_01v8_hvt w=1e+06u l=150000u
X8 VGND a_91_199# Y VNB sky130_fd_pr__nfet_01v8 w=650000u l=150000u
X9 Y A VGND VNB sky130_fd_pr__nfet_01v8 w=650000u l=150000u
.ends
.subckt sky130_fd_sc_hd__o2111a_1 A1 A2 B1 C1 D1 VGND VNB VPB VPWR X
X0 VPWR D1 a_79_21# VPB sky130_fd_pr__pfet_01v8_hvt w=1e+06u l=150000u
X1 a_306_47# C1 a_409_47# VNB sky130_fd_pr__nfet_01v8 w=650000u l=150000u
X2 VGND A1 a_512_47# VNB sky130_fd_pr__nfet_01v8 w=650000u l=150000u
X3 a_79_21# D1 a_306_47# VNB sky130_fd_pr__nfet_01v8 w=650000u l=150000u
X4 a_512_47# A2 VGND VNB sky130_fd_pr__nfet_01v8 w=650000u l=150000u
X5 VPWR B1 a_79_21# VPB sky130_fd_pr__pfet_01v8_hvt w=1e+06u l=150000u
X6 a_79_21# C1 VPWR VPB sky130_fd_pr__pfet_01v8_hvt w=1e+06u l=150000u
X7 a_79_21# A2 a_676_297# VPB sky130_fd_pr__pfet_01v8_hvt w=1e+06u l=150000u
X8 a_676_297# A1 VPWR VPB sky130_fd_pr__pfet_01v8_hvt w=1e+06u l=150000u
X9 a_409_47# B1 a_512_47# VNB sky130_fd_pr__nfet_01v8 w=650000u l=150000u
X10 X a_79_21# VGND VNB sky130_fd_pr__nfet_01v8 w=650000u l=150000u
X11 X a_79_21# VPWR VPB sky130_fd_pr__pfet_01v8_hvt w=1e+06u l=150000u
.ends
.subckt sky130_fd_sc_hd__o211ai_1 A1 A2 B1 C1 VGND VNB VPB VPWR Y
X0 a_110_297# A2 Y VPB sky130_fd_pr__pfet_01v8_hvt w=1e+06u l=150000u
X1 VPWR A1 a_110_297# VPB sky130_fd_pr__pfet_01v8_hvt w=1e+06u l=150000u
X2 a_27_47# A1 VGND VNB sky130_fd_pr__nfet_01v8 w=650000u l=150000u
X3 a_326_47# C1 Y VNB sky130_fd_pr__nfet_01v8 w=650000u l=150000u
X4 VPWR C1 Y VPB sky130_fd_pr__pfet_01v8_hvt w=1e+06u l=150000u
X5 VGND A2 a_27_47# VNB sky130_fd_pr__nfet_01v8 w=650000u l=150000u
X6 a_27_47# B1 a_326_47# VNB sky130_fd_pr__nfet_01v8 w=650000u l=150000u
X7 Y B1 VPWR VPB sky130_fd_pr__pfet_01v8_hvt w=1e+06u l=150000u
.ends
.subckt sky130_fd_sc_hd__o21a_1 A1 A2 B1 VGND VNB VPB VPWR X
X0 a_382_297# A1 VPWR VPB sky130_fd_pr__pfet_01v8_hvt w=1e+06u l=150000u
X1 VGND A1 a_297_47# VNB sky130_fd_pr__nfet_01v8 w=650000u l=150000u
X2 a_79_21# B1 a_297_47# VNB sky130_fd_pr__nfet_01v8 w=650000u l=150000u
X3 X a_79_21# VPWR VPB sky130_fd_pr__pfet_01v8_hvt w=1e+06u l=150000u
X4 a_297_47# A2 VGND VNB sky130_fd_pr__nfet_01v8 w=650000u l=150000u
X5 a_79_21# A2 a_382_297# VPB sky130_fd_pr__pfet_01v8_hvt w=1e+06u l=150000u
X6 VPWR B1 a_79_21# VPB sky130_fd_pr__pfet_01v8_hvt w=1e+06u l=150000u
X7 X a_79_21# VGND VNB sky130_fd_pr__nfet_01v8 w=650000u l=150000u
.ends
.subckt sky130_fd_sc_hd__o21ai_0 A1 A2 B1 VGND VNB VPB VPWR Y
X0 VGND A2 a_32_47# VNB sky130_fd_pr__nfet_01v8 w=420000u l=150000u
X1 Y B1 VPWR VPB sky130_fd_pr__pfet_01v8_hvt w=640000u l=150000u
X2 a_32_47# B1 Y VNB sky130_fd_pr__nfet_01v8 w=420000u l=150000u
X3 a_32_47# A1 VGND VNB sky130_fd_pr__nfet_01v8 w=420000u l=150000u
X4 VPWR A1 a_120_369# VPB sky130_fd_pr__pfet_01v8_hvt w=640000u l=150000u
X5 a_120_369# A2 Y VPB sky130_fd_pr__pfet_01v8_hvt w=640000u l=150000u
.ends
.subckt sky130_fd_sc_hd__o311ai_0 A1 A2 A3 B1 C1 VGND VNB VPB VPWR Y
X0 a_138_47# B1 a_458_47# VNB sky130_fd_pr__nfet_01v8 w=420000u l=150000u
X1 VPWR A1 a_138_369# VPB sky130_fd_pr__pfet_01v8_hvt w=640000u l=150000u
X2 VGND A3 a_138_47# VNB sky130_fd_pr__nfet_01v8 w=420000u l=150000u
X3 VGND A1 a_138_47# VNB sky130_fd_pr__nfet_01v8 w=420000u l=150000u
X4 a_458_47# C1 Y VNB sky130_fd_pr__nfet_01v8 w=420000u l=150000u
X5 a_138_47# A2 VGND VNB sky130_fd_pr__nfet_01v8 w=420000u l=150000u
X6 Y B1 VPWR VPB sky130_fd_pr__pfet_01v8_hvt w=640000u l=150000u
X7 a_222_369# A3 Y VPB sky130_fd_pr__pfet_01v8_hvt w=640000u l=150000u
X8 VPWR C1 Y VPB sky130_fd_pr__pfet_01v8_hvt w=640000u l=150000u
X9 a_138_369# A2 a_222_369# VPB sky130_fd_pr__pfet_01v8_hvt w=640000u l=150000u
.ends
.subckt sky130_fd_sc_hd__or2_0 A B VGND VNB VPB VPWR X
X0 VGND a_68_355# X VNB sky130_fd_pr__nfet_01v8 w=420000u l=150000u
X1 a_150_355# A VPWR VPB sky130_fd_pr__pfet_01v8_hvt w=420000u l=150000u
X2 VGND B a_68_355# VNB sky130_fd_pr__nfet_01v8 w=420000u l=150000u
X3 a_68_355# A VGND VNB sky130_fd_pr__nfet_01v8 w=420000u l=150000u
X4 a_68_355# B a_150_355# VPB sky130_fd_pr__pfet_01v8_hvt w=420000u l=150000u
X5 VPWR a_68_355# X VPB sky130_fd_pr__pfet_01v8_hvt w=640000u l=150000u
.ends
.subckt sky130_fd_sc_hd__or3_1 A B C VGND VNB VPB VPWR X
X0 VPWR a_29_53# X VPB sky130_fd_pr__pfet_01v8_hvt w=1e+06u l=150000u
X1 a_111_297# B a_183_297# VPB sky130_fd_pr__pfet_01v8_hvt w=420000u l=150000u
X2 a_29_53# C a_111_297# VPB sky130_fd_pr__pfet_01v8_hvt w=420000u l=150000u
X3 VGND a_29_53# X VNB sky130_fd_pr__nfet_01v8 w=650000u l=150000u
X4 a_29_53# C VGND VNB sky130_fd_pr__nfet_01v8 w=420000u l=150000u
X5 a_29_53# A VGND VNB sky130_fd_pr__nfet_01v8 w=420000u l=150000u
X6 a_183_297# A VPWR VPB sky130_fd_pr__pfet_01v8_hvt w=420000u l=150000u
X7 VGND B a_29_53# VNB sky130_fd_pr__nfet_01v8 w=420000u l=150000u
.ends
.subckt sky130_fd_sc_hd__or3b_1 A B C_N VGND VNB VPB VPWR X
X0 a_215_53# a_109_93# VGND VNB sky130_fd_pr__nfet_01v8 w=420000u l=150000u
X1 VGND a_215_53# X VNB sky130_fd_pr__nfet_01v8 w=650000u l=150000u
X2 a_215_53# a_109_93# a_297_297# VPB sky130_fd_pr__pfet_01v8_hvt w=420000u l=150000u
X3 a_297_297# B a_369_297# VPB sky130_fd_pr__pfet_01v8_hvt w=420000u l=150000u
X4 a_369_297# A VPWR VPB sky130_fd_pr__pfet_01v8_hvt w=420000u l=150000u
X5 VPWR a_215_53# X VPB sky130_fd_pr__pfet_01v8_hvt w=1e+06u l=150000u
X6 a_215_53# A VGND VNB sky130_fd_pr__nfet_01v8 w=420000u l=150000u
X7 VGND C_N a_109_93# VNB sky130_fd_pr__nfet_01v8 w=420000u l=150000u
X8 VGND B a_215_53# VNB sky130_fd_pr__nfet_01v8 w=420000u l=150000u
X9 VPWR C_N a_109_93# VPB sky130_fd_pr__pfet_01v8_hvt w=420000u l=150000u
.ends
.subckt sky130_fd_sc_hd__or4b_1 A B C D_N VGND VNB VPB VPWR X
X0 VGND a_109_53# a_215_297# VNB sky130_fd_pr__nfet_01v8 w=420000u l=150000u
X1 a_215_297# A VGND VNB sky130_fd_pr__nfet_01v8 w=420000u l=150000u
X2 VGND B a_215_297# VNB sky130_fd_pr__nfet_01v8 w=420000u l=150000u
X3 a_297_297# C a_392_297# VPB sky130_fd_pr__pfet_01v8_hvt w=420000u l=150000u
X4 a_215_297# a_109_53# a_297_297# VPB sky130_fd_pr__pfet_01v8_hvt w=420000u l=150000u
X5 a_392_297# B a_465_297# VPB sky130_fd_pr__pfet_01v8_hvt w=420000u l=150000u
X6 VGND a_215_297# X VNB sky130_fd_pr__nfet_01v8 w=650000u l=150000u
X7 VGND D_N a_109_53# VNB sky130_fd_pr__nfet_01v8 w=420000u l=150000u
X8 a_215_297# C VGND VNB sky130_fd_pr__nfet_01v8 w=420000u l=150000u
X9 VPWR D_N a_109_53# VPB sky130_fd_pr__pfet_01v8_hvt w=420000u l=150000u
X10 a_465_297# A VPWR VPB sky130_fd_pr__pfet_01v8_hvt w=420000u l=150000u
X11 VPWR a_215_297# X VPB sky130_fd_pr__pfet_01v8_hvt w=1e+06u l=150000u
.ends
.subckt sky130_fd_sc_hd__xnor2_1 A B VGND VNB VPB VPWR Y
X0 VPWR A a_377_297# VPB sky130_fd_pr__pfet_01v8_hvt w=1e+06u l=150000u
X1 a_377_297# B Y VPB sky130_fd_pr__pfet_01v8_hvt w=1e+06u l=150000u
X2 Y a_47_47# VPWR VPB sky130_fd_pr__pfet_01v8_hvt w=1e+06u l=150000u
X3 a_129_47# A VGND VNB sky130_fd_pr__nfet_01v8 w=650000u l=150000u
X4 VGND B a_285_47# VNB sky130_fd_pr__nfet_01v8 w=650000u l=150000u
X5 a_47_47# B a_129_47# VNB sky130_fd_pr__nfet_01v8 w=650000u l=150000u
X6 VPWR B a_47_47# VPB sky130_fd_pr__pfet_01v8_hvt w=1e+06u l=150000u
X7 a_47_47# A VPWR VPB sky130_fd_pr__pfet_01v8_hvt w=1e+06u l=150000u
X8 VGND A a_285_47# VNB sky130_fd_pr__nfet_01v8 w=650000u l=150000u
X9 a_285_47# a_47_47# Y VNB sky130_fd_pr__nfet_01v8 w=650000u l=150000u
.ends
.subckt sky130_fd_sc_hd__xor2_1 A B VGND VNB VPB VPWR X
X0 a_35_297# A VGND VNB sky130_fd_pr__nfet_01v8 w=650000u l=150000u
X1 VGND B a_35_297# VNB sky130_fd_pr__nfet_01v8 w=650000u l=150000u
X2 X a_35_297# VGND VNB sky130_fd_pr__nfet_01v8 w=650000u l=150000u
X3 a_285_297# B VPWR VPB sky130_fd_pr__pfet_01v8_hvt w=1e+06u l=150000u
X4 VPWR A a_285_297# VPB sky130_fd_pr__pfet_01v8_hvt w=1e+06u l=150000u
X5 a_35_297# B a_117_297# VPB sky130_fd_pr__pfet_01v8_hvt w=1e+06u l=150000u
X6 a_117_297# A VPWR VPB sky130_fd_pr__pfet_01v8_hvt w=1e+06u l=150000u
X7 a_285_47# B X VNB sky130_fd_pr__nfet_01v8 w=650000u l=150000u
X8 a_285_297# a_35_297# X VPB sky130_fd_pr__pfet_01v8_hvt w=1e+06u l=150000u
X9 VGND A a_285_47# VNB sky130_fd_pr__nfet_01v8 w=650000u l=150000u
.ends
