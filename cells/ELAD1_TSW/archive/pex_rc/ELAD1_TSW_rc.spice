* SPICE3 file created from ELAD1_TSW_flat.ext - technology: sky130A

X0 B.t6 ENB.t4 ELAD1_TGA_0.B.t12 VDPWR.t4 sky130_fd_pr__pfet_01v8_lvt ad=0.75 pd=3.5 as=0.9 ps=6.6 w=3 l=0.35
X1 B.t1 ENB.t2 ELAD1_TGA_0.B.t14 VDPWR.t6 sky130_fd_pr__pfet_01v8_lvt ad=0.75 pd=3.5 as=0.75 ps=3.5 w=3 l=0.35
X2 ELAD1_TGA_0.B.t16 ENB.t0 VGND.t9 VGND.t8 sky130_fd_pr__nfet_01v8 ad=0.3 pd=2.6 as=0.3 ps=2.6 w=1 l=0.15
X3 A.t4 EN.t5 ELAD1_TGA_0.B.t2 VGND.t2 sky130_fd_pr__nfet_01v8_lvt ad=0.25 pd=1.5 as=0.25 ps=1.5 w=1 l=0.15
X4 ELAD1_TGA_0.B.t1 EN.t6 A.t5 VGND.t1 sky130_fd_pr__nfet_01v8_lvt ad=0.25 pd=1.5 as=0.25 ps=1.5 w=1 l=0.15
X5 A.t1 ENB.t7 ELAD1_TGA_0.B.t9 VDPWR.t1 sky130_fd_pr__pfet_01v8_lvt ad=0.75 pd=3.5 as=0.75 ps=3.5 w=3 l=0.35
X6 A.t6 EN.t7 ELAD1_TGA_0.B.t0 VGND.t0 sky130_fd_pr__nfet_01v8_lvt ad=0.25 pd=1.5 as=0.3 ps=2.6 w=1 l=0.15
X7 A.t7 ENB.t5 ELAD1_TGA_0.B.t11 VDPWR.t3 sky130_fd_pr__pfet_01v8_lvt ad=0.9 pd=6.6 as=0.75 ps=3.5 w=3 l=0.35
X8 ELAD1_TGA_0.B.t3 EN.t4 A.t3 VGND.t3 sky130_fd_pr__nfet_01v8_lvt ad=0.3 pd=2.6 as=0.25 ps=1.5 w=1 l=0.15
X9 ELAD1_TGA_0.B.t13 ENB.t3 B.t7 VDPWR.t5 sky130_fd_pr__pfet_01v8_lvt ad=0.75 pd=3.5 as=0.75 ps=3.5 w=3 l=0.35
X10 B.t4 EN.t0 ELAD1_TGA_0.B.t7 VGND.t7 sky130_fd_pr__nfet_01v8_lvt ad=0.3 pd=2.6 as=0.25 ps=1.5 w=1 l=0.15
X11 ELAD1_TGA_0.B.t6 EN.t1 B.t2 VGND.t6 sky130_fd_pr__nfet_01v8_lvt ad=0.25 pd=1.5 as=0.25 ps=1.5 w=1 l=0.15
X12 B.t5 EN.t2 ELAD1_TGA_0.B.t5 VGND.t5 sky130_fd_pr__nfet_01v8_lvt ad=0.25 pd=1.5 as=0.25 ps=1.5 w=1 l=0.15
X13 ELAD1_TGA_0.B.t4 EN.t3 B.t3 VGND.t4 sky130_fd_pr__nfet_01v8_lvt ad=0.25 pd=1.5 as=0.3 ps=2.6 w=1 l=0.15
X14 ELAD1_TGA_0.B.t15 ENB.t1 B.t0 VDPWR.t7 sky130_fd_pr__pfet_01v8_lvt ad=0.9 pd=6.6 as=0.75 ps=3.5 w=3 l=0.35
X15 ELAD1_TGA_0.B.t8 ENB.t8 A.t0 VDPWR.t0 sky130_fd_pr__pfet_01v8_lvt ad=0.75 pd=3.5 as=0.9 ps=6.6 w=3 l=0.35
X16 ELAD1_TGA_0.B.t10 ENB.t6 A.t2 VDPWR.t2 sky130_fd_pr__pfet_01v8_lvt ad=0.75 pd=3.5 as=0.75 ps=3.5 w=3 l=0.35
C0 B ENB 0.57395f
C1 A VDPWR 0.95084f
C2 VDPWR ELAD1_TGA_0.B 1.3759f
C3 A ENB 0.59129f
C4 ENB ELAD1_TGA_0.B 1.23008f
C5 B EN 0.30442f
C6 A EN 0.24916f
C7 EN ELAD1_TGA_0.B 0.60038f
C8 B A 0.1971f
C9 B ELAD1_TGA_0.B 3.02301f
C10 ENB VDPWR 1.81105f
C11 A ELAD1_TGA_0.B 2.8787f
C12 EN VDPWR 0.00514f
C13 ENB EN 0.07052f
C14 B VDPWR 0.42105f
R0 EN.n0 EN.t0 416.043
R1 EN.n0 EN.t1 415.69
R2 EN.n1 EN.t2 415.69
R3 EN.n2 EN.t3 415.69
R4 EN.n3 EN.t4 415.69
R5 EN.n4 EN.t5 415.69
R6 EN.n5 EN.t6 415.69
R7 EN.n6 EN.t7 415.69
R8 EN.n3 EN.n2 17.0863
R9 EN EN.n6 0.883652
R10 EN.n6 EN.n5 0.353761
R11 EN.n5 EN.n4 0.353761
R12 EN.n4 EN.n3 0.353761
R13 EN.n2 EN.n1 0.353761
R14 EN.n1 EN.n0 0.353761
R15 B.n31 B.n5 585
R16 B.n31 B.n30 585
R17 B.n68 B.n41 285.877
R18 B.n69 B.n68 285.877
R19 B.n68 B.n42 285.877
R20 B.n68 B.n67 285.877
R21 B.n32 B.n31 285.877
R22 B.n31 B.n4 285.877
R23 B.n31 B.n6 285.877
R24 B.n35 B.t4 136.989
R25 B.n75 B.t3 136.881
R26 B.n37 B.n36 103.132
R27 B.n36 B.t5 30.0005
R28 B.n36 B.t2 30.0005
R29 B.n56 B.n40 27.1064
R30 B.n59 B.n43 27.1064
R31 B.n66 B.n44 27.1064
R32 B.n15 B.n3 27.1064
R33 B.n18 B.n5 27.1064
R34 B.n24 B.n5 27.1064
R35 B.n30 B.n7 27.1064
R36 B.n47 B.n41 22.5711
R37 B.n70 B.n69 22.5471
R38 B.n33 B.n32 22.5471
R39 B.n68 B.t6 16.4172
R40 B.n68 B.t7 16.4172
R41 B.n31 B.t1 16.4172
R42 B.n31 B.t0 16.4172
R43 B.n69 B.n40 13.2471
R44 B.n59 B.n42 13.2471
R45 B.n67 B.n66 13.2471
R46 B.n44 B.n41 13.2471
R47 B.n56 B.n42 13.2471
R48 B.n67 B.n43 13.2471
R49 B.n32 B.n3 13.2471
R50 B.n18 B.n4 13.2471
R51 B.n7 B.n6 13.2471
R52 B.n15 B.n4 13.2471
R53 B.n24 B.n6 13.2471
R54 B.n30 B.n29 9.32454
R55 B.n48 B.n44 9.3005
R56 B.n66 B.n65 9.3005
R57 B.n46 B.n43 9.3005
R58 B.n60 B.n59 9.3005
R59 B.n57 B.n56 9.3005
R60 B.n53 B.n40 9.3005
R61 B.n12 B.n3 9.3005
R62 B.n16 B.n15 9.3005
R63 B.n19 B.n18 9.3005
R64 B.n10 B.n5 9.3005
R65 B.n25 B.n24 9.3005
R66 B.n8 B.n7 9.3005
R67 B.n50 B.n47 4.65435
R68 B.n74 B.n73 4.65435
R69 B.n29 B.n28 4.61815
R70 B.n71 B.n70 4.54377
R71 B.n34 B.n33 4.54377
R72 B.n73 B.n72 4.5005
R73 B.n50 B.n49 4.5005
R74 B.n51 B.n45 4.5005
R75 B.n64 B.n63 4.5005
R76 B.n62 B.n61 4.5005
R77 B.n58 B.n52 4.5005
R78 B.n55 B.n54 4.5005
R79 B.n39 B.n38 4.5005
R80 B.n2 B.n1 4.5005
R81 B.n14 B.n13 4.5005
R82 B.n17 B.n11 4.5005
R83 B.n21 B.n20 4.5005
R84 B.n23 B.n22 4.5005
R85 B.n26 B.n9 4.5005
R86 B.n28 B.n27 4.5005
R87 B.n76 B.n0 3.46747
R88 B.n76 B.n75 3.45398
R89 B.n37 B.n35 2.64442
R90 B.n35 B.n34 1.50816
R91 B.n72 B.n71 1.38616
R92 B B.n76 1.10144
R93 B.n73 B.n37 0.41323
R94 B.n71 B.n38 0.154346
R95 B.n54 B.n38 0.154346
R96 B.n54 B.n52 0.154346
R97 B.n62 B.n52 0.154346
R98 B.n63 B.n62 0.154346
R99 B.n63 B.n51 0.154346
R100 B.n51 B.n50 0.154346
R101 B.n49 B.n45 0.154346
R102 B.n27 B.n26 0.154346
R103 B.n48 B.n47 0.149538
R104 B.n29 B.n8 0.149538
R105 B.n65 B.n64 0.139923
R106 B.n25 B.n23 0.139923
R107 B.n61 B.n46 0.120692
R108 B.n20 B.n10 0.120692
R109 B.n34 B.n1 0.118147
R110 B.n13 B.n1 0.118147
R111 B.n13 B.n11 0.118147
R112 B.n21 B.n11 0.118147
R113 B.n22 B.n21 0.118147
R114 B.n22 B.n9 0.118147
R115 B.n28 B.n9 0.118147
R116 B.n70 B.n39 0.111077
R117 B.n33 B.n2 0.111077
R118 B.n60 B.n58 0.101462
R119 B.n19 B.n17 0.101462
R120 B.n74 B.n0 0.0965145
R121 B.n55 B.n53 0.0918462
R122 B.n14 B.n12 0.0918462
R123 B.n57 B.n55 0.0822308
R124 B.n16 B.n14 0.0822308
R125 B.n58 B.n57 0.0726154
R126 B.n17 B.n16 0.0726154
R127 B.n53 B.n39 0.063
R128 B.n12 B.n2 0.063
R129 B.n61 B.n60 0.0533846
R130 B.n20 B.n19 0.0533846
R131 B.n64 B.n46 0.0341538
R132 B.n23 B.n10 0.0341538
R133 B.n72 B.n0 0.0204275
R134 B.n65 B.n45 0.0149231
R135 B.n26 B.n25 0.0149231
R136 B.n75 B.n74 0.00593478
R137 B.n49 B.n48 0.00530769
R138 B.n27 B.n8 0.00530769
R139 A.n32 A.n31 585
R140 A.n5 A.n4 585
R141 A.n22 A.n21 585
R142 A.n20 A.n10 585
R143 A.n103 A.n102 585
R144 A.n76 A.n75 585
R145 A.n93 A.n92 585
R146 A.n91 A.n81 585
R147 A.n33 A.n32 571.606
R148 A.n20 A.n19 571.606
R149 A.n104 A.n103 571.606
R150 A.n91 A.n90 571.606
R151 A.n68 A.n67 285.877
R152 A.n67 A.n40 285.877
R153 A.n67 A.n41 285.877
R154 A.n67 A.n66 285.877
R155 A.n32 A.n4 236.4
R156 A.n21 A.n20 236.4
R157 A.n103 A.n75 236.4
R158 A.n92 A.n91 236.4
R159 A.t0 A.n4 118.201
R160 A.n21 A.t0 118.201
R161 A.t7 A.n75 118.201
R162 A.n92 A.t7 118.201
R163 A.n109 A.n108 102.648
R164 A.n111 A.n110 102.648
R165 A.n108 A.t4 30.0005
R166 A.n108 A.t3 30.0005
R167 A.n110 A.t6 30.0005
R168 A.n110 A.t5 30.0005
R169 A.n31 A.n3 27.1064
R170 A.n31 A.n5 27.1064
R171 A.n22 A.n5 27.1064
R172 A.n22 A.n10 27.1064
R173 A.n18 A.n10 27.1064
R174 A.n102 A.n74 27.1064
R175 A.n102 A.n76 27.1064
R176 A.n93 A.n76 27.1064
R177 A.n93 A.n81 27.1064
R178 A.n89 A.n81 27.1064
R179 A.n48 A.n39 27.1064
R180 A.n57 A.n56 27.1064
R181 A.n65 A.n43 27.1064
R182 A.n19 A.n11 24.8567
R183 A.n90 A.n82 24.8567
R184 A.n34 A.n33 24.8327
R185 A.n105 A.n104 24.8327
R186 A.n66 A.n42 22.5711
R187 A.n69 A.n68 22.5471
R188 A.n67 A.t1 16.4172
R189 A.n67 A.t2 16.4172
R190 A.n68 A.n39 13.2471
R191 A.n56 A.n40 13.2471
R192 A.n43 A.n41 13.2471
R193 A.n66 A.n65 13.2471
R194 A.n48 A.n40 13.2471
R195 A.n57 A.n41 13.2471
R196 A.n33 A.n3 11.0627
R197 A.n19 A.n18 11.0627
R198 A.n104 A.n74 11.0627
R199 A.n90 A.n89 11.0627
R200 A.n18 A.n17 9.3005
R201 A.n12 A.n10 9.3005
R202 A.n23 A.n22 9.3005
R203 A.n24 A.n5 9.3005
R204 A.n31 A.n30 9.3005
R205 A.n7 A.n3 9.3005
R206 A.n78 A.n74 9.3005
R207 A.n102 A.n101 9.3005
R208 A.n95 A.n76 9.3005
R209 A.n94 A.n93 9.3005
R210 A.n83 A.n81 9.3005
R211 A.n89 A.n88 9.3005
R212 A.n50 A.n39 9.3005
R213 A.n49 A.n48 9.3005
R214 A.n56 A.n55 9.3005
R215 A.n58 A.n57 9.3005
R216 A.n46 A.n43 9.3005
R217 A.n65 A.n64 9.3005
R218 A.n15 A.n11 4.65435
R219 A.n86 A.n82 4.65435
R220 A.n62 A.n42 4.65435
R221 A.n113 A.n112 4.57983
R222 A.n35 A.n34 4.54377
R223 A.n106 A.n105 4.54377
R224 A.n70 A.n69 4.54377
R225 A.n36 A.n0 4.5005
R226 A.n16 A.n15 4.5005
R227 A.n14 A.n13 4.5005
R228 A.n9 A.n8 4.5005
R229 A.n26 A.n25 4.5005
R230 A.n27 A.n6 4.5005
R231 A.n29 A.n28 4.5005
R232 A.n2 A.n1 4.5005
R233 A.n73 A.n72 4.5005
R234 A.n100 A.n99 4.5005
R235 A.n98 A.n77 4.5005
R236 A.n97 A.n96 4.5005
R237 A.n80 A.n79 4.5005
R238 A.n85 A.n84 4.5005
R239 A.n87 A.n86 4.5005
R240 A.n38 A.n37 4.5005
R241 A.n52 A.n51 4.5005
R242 A.n54 A.n53 4.5005
R243 A.n47 A.n45 4.5005
R244 A.n60 A.n59 4.5005
R245 A.n61 A.n44 4.5005
R246 A.n63 A.n62 4.5005
R247 A.n109 A.n107 3.65487
R248 A.n112 A.n111 3.61748
R249 A.n71 A.n70 3.28132
R250 A.n107 A.n71 3.09623
R251 A.n107 A.n106 1.10277
R252 A.n36 A.n35 1.06624
R253 A.n71 A.n0 0.802653
R254 A.n111 A.n109 0.6255
R255 A A.n113 0.291365
R256 A.n113 A.n0 0.154346
R257 A.n35 A.n1 0.154346
R258 A.n28 A.n1 0.154346
R259 A.n28 A.n27 0.154346
R260 A.n27 A.n26 0.154346
R261 A.n26 A.n8 0.154346
R262 A.n14 A.n8 0.154346
R263 A.n15 A.n14 0.154346
R264 A.n16 A.n13 0.154346
R265 A.n106 A.n72 0.154346
R266 A.n99 A.n72 0.154346
R267 A.n99 A.n98 0.154346
R268 A.n98 A.n97 0.154346
R269 A.n97 A.n79 0.154346
R270 A.n85 A.n79 0.154346
R271 A.n86 A.n85 0.154346
R272 A.n87 A.n84 0.154346
R273 A.n70 A.n37 0.154346
R274 A.n52 A.n37 0.154346
R275 A.n53 A.n52 0.154346
R276 A.n53 A.n45 0.154346
R277 A.n60 A.n45 0.154346
R278 A.n61 A.n60 0.154346
R279 A.n62 A.n61 0.154346
R280 A.n63 A.n44 0.154346
R281 A.n17 A.n11 0.149538
R282 A.n88 A.n82 0.149538
R283 A.n64 A.n42 0.149538
R284 A.n12 A.n9 0.139923
R285 A.n83 A.n80 0.139923
R286 A.n59 A.n46 0.139923
R287 A.n25 A.n23 0.120692
R288 A.n96 A.n94 0.120692
R289 A.n58 A.n47 0.120692
R290 A.n34 A.n2 0.111077
R291 A.n105 A.n73 0.111077
R292 A.n69 A.n38 0.111077
R293 A.n24 A.n6 0.101462
R294 A.n95 A.n77 0.101462
R295 A.n55 A.n54 0.101462
R296 A.n29 A.n7 0.0918462
R297 A.n100 A.n78 0.0918462
R298 A.n51 A.n50 0.0918462
R299 A.n30 A.n29 0.0822308
R300 A.n101 A.n100 0.0822308
R301 A.n51 A.n49 0.0822308
R302 A.n112 A.n36 0.0750192
R303 A.n30 A.n6 0.0726154
R304 A.n101 A.n77 0.0726154
R305 A.n54 A.n49 0.0726154
R306 A.n7 A.n2 0.063
R307 A.n78 A.n73 0.063
R308 A.n50 A.n38 0.063
R309 A.n25 A.n24 0.0533846
R310 A.n96 A.n95 0.0533846
R311 A.n55 A.n47 0.0533846
R312 A.n23 A.n9 0.0341538
R313 A.n94 A.n80 0.0341538
R314 A.n59 A.n58 0.0341538
R315 A.n13 A.n12 0.0149231
R316 A.n84 A.n83 0.0149231
R317 A.n46 A.n44 0.0149231
R318 A.n17 A.n16 0.00530769
R319 A.n88 A.n87 0.00530769
R320 A.n64 A.n63 0.00530769
R321 ENB.n3 ENB.t0 426.312
R322 ENB.n0 ENB.t1 418.599
R323 ENB.n0 ENB.t2 418.137
R324 ENB.n1 ENB.t3 418.137
R325 ENB.n2 ENB.t4 418.137
R326 ENB.n4 ENB.t5 418.137
R327 ENB.n5 ENB.t6 418.137
R328 ENB.n6 ENB.t7 418.137
R329 ENB.n7 ENB.t8 418.137
R330 ENB.n3 ENB.n2 1.05568
R331 ENB.n4 ENB.n3 1.04481
R332 ENB ENB.n7 0.720609
R333 ENB.n7 ENB.n6 0.462457
R334 ENB.n6 ENB.n5 0.462457
R335 ENB.n5 ENB.n4 0.462457
R336 ENB.n2 ENB.n1 0.462457
R337 ENB.n1 ENB.n0 0.462457
R338 VDPWR.n140 VDPWR.n139 705.883
R339 VDPWR.n84 VDPWR.n72 705.883
R340 VDPWR.n157 VDPWR.n47 705.883
R341 VDPWR.n100 VDPWR.n74 705.883
R342 VDPWR.n222 VDPWR.n9 705.883
R343 VDPWR.n166 VDPWR.n35 705.883
R344 VDPWR.n236 VDPWR.n3 705.883
R345 VDPWR.n182 VDPWR.n37 705.883
R346 VDPWR.n159 VDPWR.n158 343.308
R347 VDPWR.n144 VDPWR.n143 254.119
R348 VDPWR.n148 VDPWR.n147 254.119
R349 VDPWR.n150 VDPWR.n42 254.119
R350 VDPWR.n153 VDPWR.n42 254.119
R351 VDPWR.n157 VDPWR.n48 254.119
R352 VDPWR.n139 VDPWR.n138 254.119
R353 VDPWR.n138 VDPWR.n51 254.119
R354 VDPWR.n126 VDPWR.n51 254.119
R355 VDPWR.n126 VDPWR.n59 254.119
R356 VDPWR.n121 VDPWR.n59 254.119
R357 VDPWR.n121 VDPWR.n61 254.119
R358 VDPWR.n111 VDPWR.n61 254.119
R359 VDPWR.n111 VDPWR.n70 254.119
R360 VDPWR.n107 VDPWR.n70 254.119
R361 VDPWR.n107 VDPWR.n72 254.119
R362 VDPWR.n88 VDPWR.n82 254.119
R363 VDPWR.n91 VDPWR.n90 254.119
R364 VDPWR.n95 VDPWR.n79 254.119
R365 VDPWR.n98 VDPWR.n97 254.119
R366 VDPWR.n136 VDPWR.n47 254.119
R367 VDPWR.n136 VDPWR.n53 254.119
R368 VDPWR.n129 VDPWR.n53 254.119
R369 VDPWR.n129 VDPWR.n58 254.119
R370 VDPWR.n119 VDPWR.n58 254.119
R371 VDPWR.n119 VDPWR.n64 254.119
R372 VDPWR.n113 VDPWR.n64 254.119
R373 VDPWR.n113 VDPWR.n68 254.119
R374 VDPWR.n105 VDPWR.n68 254.119
R375 VDPWR.n105 VDPWR.n74 254.119
R376 VDPWR.n225 VDPWR.n9 254.119
R377 VDPWR.n229 VDPWR.n228 254.119
R378 VDPWR.n233 VDPWR.n11 254.119
R379 VDPWR.n233 VDPWR.n10 254.119
R380 VDPWR.n12 VDPWR.n4 254.119
R381 VDPWR.n222 VDPWR.n221 254.119
R382 VDPWR.n221 VDPWR.n16 254.119
R383 VDPWR.n210 VDPWR.n16 254.119
R384 VDPWR.n210 VDPWR.n22 254.119
R385 VDPWR.n205 VDPWR.n22 254.119
R386 VDPWR.n205 VDPWR.n24 254.119
R387 VDPWR.n195 VDPWR.n24 254.119
R388 VDPWR.n195 VDPWR.n33 254.119
R389 VDPWR.n191 VDPWR.n33 254.119
R390 VDPWR.n191 VDPWR.n35 254.119
R391 VDPWR.n170 VDPWR.n164 254.119
R392 VDPWR.n173 VDPWR.n172 254.119
R393 VDPWR.n177 VDPWR.n161 254.119
R394 VDPWR.n180 VDPWR.n179 254.119
R395 VDPWR.n219 VDPWR.n3 254.119
R396 VDPWR.n219 VDPWR.n17 254.119
R397 VDPWR.n213 VDPWR.n17 254.119
R398 VDPWR.n213 VDPWR.n21 254.119
R399 VDPWR.n203 VDPWR.n21 254.119
R400 VDPWR.n203 VDPWR.n27 254.119
R401 VDPWR.n197 VDPWR.n27 254.119
R402 VDPWR.n197 VDPWR.n31 254.119
R403 VDPWR.n189 VDPWR.n31 254.119
R404 VDPWR.n189 VDPWR.n37 254.119
R405 VDPWR.n47 VDPWR.n41 185
R406 VDPWR.n55 VDPWR.n47 185
R407 VDPWR.n137 VDPWR.n136 185
R408 VDPWR.n136 VDPWR.n135 185
R409 VDPWR.n127 VDPWR.n53 185
R410 VDPWR.n54 VDPWR.n53 185
R411 VDPWR.n129 VDPWR.n128 185
R412 VDPWR.n130 VDPWR.n129 185
R413 VDPWR.n63 VDPWR.n58 185
R414 VDPWR.n58 VDPWR.n57 185
R415 VDPWR.n120 VDPWR.n119 185
R416 VDPWR.n119 VDPWR.n118 185
R417 VDPWR.n64 VDPWR.n62 185
R418 VDPWR.n65 VDPWR.n64 185
R419 VDPWR.n113 VDPWR.n112 185
R420 VDPWR.n114 VDPWR.n113 185
R421 VDPWR.n69 VDPWR.n68 185
R422 VDPWR.n68 VDPWR.n67 185
R423 VDPWR.n106 VDPWR.n105 185
R424 VDPWR.n105 VDPWR.n104 185
R425 VDPWR.n74 VDPWR.n73 185
R426 VDPWR.n75 VDPWR.n74 185
R427 VDPWR.n101 VDPWR.n100 185
R428 VDPWR.n98 VDPWR.n76 185
R429 VDPWR.n97 VDPWR.n78 185
R430 VDPWR.n95 VDPWR.n94 185
R431 VDPWR.n93 VDPWR.n79 185
R432 VDPWR.n92 VDPWR.n91 185
R433 VDPWR.n90 VDPWR.n80 185
R434 VDPWR.n88 VDPWR.n87 185
R435 VDPWR.n86 VDPWR.n82 185
R436 VDPWR.n85 VDPWR.n84 185
R437 VDPWR.n73 VDPWR.n72 185
R438 VDPWR.n72 VDPWR.n71 185
R439 VDPWR.n107 VDPWR.n106 185
R440 VDPWR.n108 VDPWR.n107 185
R441 VDPWR.n70 VDPWR.n69 185
R442 VDPWR.n109 VDPWR.n70 185
R443 VDPWR.n112 VDPWR.n111 185
R444 VDPWR.n111 VDPWR.n110 185
R445 VDPWR.n62 VDPWR.n61 185
R446 VDPWR.n61 VDPWR.n60 185
R447 VDPWR.n121 VDPWR.n120 185
R448 VDPWR.n122 VDPWR.n121 185
R449 VDPWR.n63 VDPWR.n59 185
R450 VDPWR.n123 VDPWR.n59 185
R451 VDPWR.n128 VDPWR.n126 185
R452 VDPWR.n126 VDPWR.n125 185
R453 VDPWR.n127 VDPWR.n51 185
R454 VDPWR.n124 VDPWR.n51 185
R455 VDPWR.n138 VDPWR.n137 185
R456 VDPWR.n138 VDPWR.n52 185
R457 VDPWR.n139 VDPWR.n41 185
R458 VDPWR.n139 VDPWR.n50 185
R459 VDPWR.n141 VDPWR.n140 185
R460 VDPWR.n143 VDPWR.n142 185
R461 VDPWR.n145 VDPWR.n144 185
R462 VDPWR.n147 VDPWR.n146 185
R463 VDPWR.n149 VDPWR.n148 185
R464 VDPWR.n151 VDPWR.n150 185
R465 VDPWR.n158 VDPWR.n42 185
R466 VDPWR.n152 VDPWR.n42 185
R467 VDPWR.n154 VDPWR.n153 185
R468 VDPWR.n155 VDPWR.n48 185
R469 VDPWR.n158 VDPWR.n157 185
R470 VDPWR.n157 VDPWR.n156 185
R471 VDPWR.n5 VDPWR.n3 185
R472 VDPWR.n3 VDPWR.n1 185
R473 VDPWR.n220 VDPWR.n219 185
R474 VDPWR.n219 VDPWR.n218 185
R475 VDPWR.n211 VDPWR.n17 185
R476 VDPWR.n18 VDPWR.n17 185
R477 VDPWR.n213 VDPWR.n212 185
R478 VDPWR.n214 VDPWR.n213 185
R479 VDPWR.n26 VDPWR.n21 185
R480 VDPWR.n21 VDPWR.n20 185
R481 VDPWR.n204 VDPWR.n203 185
R482 VDPWR.n203 VDPWR.n202 185
R483 VDPWR.n27 VDPWR.n25 185
R484 VDPWR.n28 VDPWR.n27 185
R485 VDPWR.n197 VDPWR.n196 185
R486 VDPWR.n198 VDPWR.n197 185
R487 VDPWR.n32 VDPWR.n31 185
R488 VDPWR.n31 VDPWR.n30 185
R489 VDPWR.n190 VDPWR.n189 185
R490 VDPWR.n189 VDPWR.n188 185
R491 VDPWR.n37 VDPWR.n36 185
R492 VDPWR.n38 VDPWR.n37 185
R493 VDPWR.n183 VDPWR.n182 185
R494 VDPWR.n180 VDPWR.n40 185
R495 VDPWR.n179 VDPWR.n160 185
R496 VDPWR.n177 VDPWR.n176 185
R497 VDPWR.n175 VDPWR.n161 185
R498 VDPWR.n174 VDPWR.n173 185
R499 VDPWR.n172 VDPWR.n162 185
R500 VDPWR.n170 VDPWR.n169 185
R501 VDPWR.n168 VDPWR.n164 185
R502 VDPWR.n167 VDPWR.n166 185
R503 VDPWR.n36 VDPWR.n35 185
R504 VDPWR.n35 VDPWR.n34 185
R505 VDPWR.n191 VDPWR.n190 185
R506 VDPWR.n192 VDPWR.n191 185
R507 VDPWR.n33 VDPWR.n32 185
R508 VDPWR.n193 VDPWR.n33 185
R509 VDPWR.n196 VDPWR.n195 185
R510 VDPWR.n195 VDPWR.n194 185
R511 VDPWR.n25 VDPWR.n24 185
R512 VDPWR.n24 VDPWR.n23 185
R513 VDPWR.n205 VDPWR.n204 185
R514 VDPWR.n206 VDPWR.n205 185
R515 VDPWR.n26 VDPWR.n22 185
R516 VDPWR.n207 VDPWR.n22 185
R517 VDPWR.n212 VDPWR.n210 185
R518 VDPWR.n210 VDPWR.n209 185
R519 VDPWR.n211 VDPWR.n16 185
R520 VDPWR.n208 VDPWR.n16 185
R521 VDPWR.n221 VDPWR.n220 185
R522 VDPWR.n221 VDPWR.n15 185
R523 VDPWR.n222 VDPWR.n5 185
R524 VDPWR.n223 VDPWR.n222 185
R525 VDPWR.n234 VDPWR.n9 185
R526 VDPWR.n224 VDPWR.n9 185
R527 VDPWR.n226 VDPWR.n225 185
R528 VDPWR.n228 VDPWR.n227 185
R529 VDPWR.n230 VDPWR.n229 185
R530 VDPWR.n231 VDPWR.n11 185
R531 VDPWR.n234 VDPWR.n233 185
R532 VDPWR.n233 VDPWR.n232 185
R533 VDPWR.n14 VDPWR.n10 185
R534 VDPWR.n13 VDPWR.n12 185
R535 VDPWR.n4 VDPWR.n2 185
R536 VDPWR.n237 VDPWR.n236 185
R537 VDPWR.n234 VDPWR.n5 87.1898
R538 VDPWR.n159 VDPWR.n36 87.1898
R539 VDPWR.n158 VDPWR.n41 87.1898
R540 VDPWR.n77 VDPWR.n73 87.1898
R541 VDPWR.n100 VDPWR.n99 75.3262
R542 VDPWR.n97 VDPWR.n96 75.3262
R543 VDPWR.n81 VDPWR.n79 75.3262
R544 VDPWR.n90 VDPWR.n89 75.3262
R545 VDPWR.n83 VDPWR.n82 75.3262
R546 VDPWR.n143 VDPWR.n44 75.3262
R547 VDPWR.n144 VDPWR.n45 75.3262
R548 VDPWR.n150 VDPWR.n43 75.3262
R549 VDPWR.n48 VDPWR.n46 75.3262
R550 VDPWR.n140 VDPWR.n44 75.3262
R551 VDPWR.n147 VDPWR.n45 75.3262
R552 VDPWR.n148 VDPWR.n43 75.3262
R553 VDPWR.n153 VDPWR.n46 75.3262
R554 VDPWR.n84 VDPWR.n83 75.3262
R555 VDPWR.n89 VDPWR.n88 75.3262
R556 VDPWR.n91 VDPWR.n81 75.3262
R557 VDPWR.n96 VDPWR.n95 75.3262
R558 VDPWR.n99 VDPWR.n98 75.3262
R559 VDPWR.n182 VDPWR.n181 75.3262
R560 VDPWR.n179 VDPWR.n178 75.3262
R561 VDPWR.n163 VDPWR.n161 75.3262
R562 VDPWR.n172 VDPWR.n171 75.3262
R563 VDPWR.n165 VDPWR.n164 75.3262
R564 VDPWR.n225 VDPWR.n8 75.3262
R565 VDPWR.n229 VDPWR.n7 75.3262
R566 VDPWR.n12 VDPWR.n6 75.3262
R567 VDPWR.n235 VDPWR.n4 75.3262
R568 VDPWR.n228 VDPWR.n8 75.3262
R569 VDPWR.n11 VDPWR.n7 75.3262
R570 VDPWR.n10 VDPWR.n6 75.3262
R571 VDPWR.n236 VDPWR.n235 75.3262
R572 VDPWR.n166 VDPWR.n165 75.3262
R573 VDPWR.n171 VDPWR.n170 75.3262
R574 VDPWR.n173 VDPWR.n163 75.3262
R575 VDPWR.n178 VDPWR.n177 75.3262
R576 VDPWR.n181 VDPWR.n180 75.3262
R577 VDPWR.n85 VDPWR.n71 75.2946
R578 VDPWR.n141 VDPWR.n50 75.2946
R579 VDPWR.n224 VDPWR.n223 75.2946
R580 VDPWR.n167 VDPWR.n34 75.2946
R581 VDPWR.n220 VDPWR.n5 65.3925
R582 VDPWR.n212 VDPWR.n211 65.3925
R583 VDPWR.n204 VDPWR.n26 65.3925
R584 VDPWR.n204 VDPWR.n25 65.3925
R585 VDPWR.n196 VDPWR.n32 65.3925
R586 VDPWR.n190 VDPWR.n36 65.3925
R587 VDPWR.n137 VDPWR.n41 65.3925
R588 VDPWR.n128 VDPWR.n127 65.3925
R589 VDPWR.n120 VDPWR.n63 65.3925
R590 VDPWR.n120 VDPWR.n62 65.3925
R591 VDPWR.n112 VDPWR.n69 65.3925
R592 VDPWR.n106 VDPWR.n73 65.3925
R593 VDPWR.n99 VDPWR.n77 54.8384
R594 VDPWR.n96 VDPWR.n77 54.8384
R595 VDPWR.n81 VDPWR.n77 54.8384
R596 VDPWR.n89 VDPWR.n77 54.8384
R597 VDPWR.n83 VDPWR.n77 54.8384
R598 VDPWR.n158 VDPWR.n44 54.8384
R599 VDPWR.n158 VDPWR.n45 54.8384
R600 VDPWR.n158 VDPWR.n43 54.8384
R601 VDPWR.n158 VDPWR.n46 54.8384
R602 VDPWR.n181 VDPWR.n159 54.8384
R603 VDPWR.n178 VDPWR.n159 54.8384
R604 VDPWR.n163 VDPWR.n159 54.8384
R605 VDPWR.n171 VDPWR.n159 54.8384
R606 VDPWR.n165 VDPWR.n159 54.8384
R607 VDPWR.n234 VDPWR.n8 54.8384
R608 VDPWR.n234 VDPWR.n7 54.8384
R609 VDPWR.n234 VDPWR.n6 54.8384
R610 VDPWR.n235 VDPWR.n234 54.8384
R611 VDPWR.n212 VDPWR.t1 53.5856
R612 VDPWR.n196 VDPWR.t2 53.5856
R613 VDPWR.n128 VDPWR.t5 53.5856
R614 VDPWR.n112 VDPWR.t6 53.5856
R615 VDPWR.n102 VDPWR.n101 50.6726
R616 VDPWR.n156 VDPWR.n49 45.8317
R617 VDPWR.n238 VDPWR.n237 45.8317
R618 VDPWR.n184 VDPWR.n183 45.8317
R619 VDPWR.n211 VDPWR.t0 35.4211
R620 VDPWR.t3 VDPWR.n32 35.4211
R621 VDPWR.n127 VDPWR.t4 35.4211
R622 VDPWR.t7 VDPWR.n69 35.4211
R623 VDPWR.n220 VDPWR.t0 29.9718
R624 VDPWR.n190 VDPWR.t3 29.9718
R625 VDPWR.n137 VDPWR.t4 29.9718
R626 VDPWR.n106 VDPWR.t7 29.9718
R627 VDPWR.n86 VDPWR.n85 27.1064
R628 VDPWR.n87 VDPWR.n86 27.1064
R629 VDPWR.n87 VDPWR.n80 27.1064
R630 VDPWR.n92 VDPWR.n80 27.1064
R631 VDPWR.n93 VDPWR.n92 27.1064
R632 VDPWR.n94 VDPWR.n93 27.1064
R633 VDPWR.n94 VDPWR.n78 27.1064
R634 VDPWR.n78 VDPWR.n76 27.1064
R635 VDPWR.n101 VDPWR.n76 27.1064
R636 VDPWR.n52 VDPWR.n50 27.1064
R637 VDPWR.n124 VDPWR.n52 27.1064
R638 VDPWR.n125 VDPWR.n124 27.1064
R639 VDPWR.n125 VDPWR.n123 27.1064
R640 VDPWR.n123 VDPWR.n122 27.1064
R641 VDPWR.n122 VDPWR.n60 27.1064
R642 VDPWR.n110 VDPWR.n60 27.1064
R643 VDPWR.n110 VDPWR.n109 27.1064
R644 VDPWR.n109 VDPWR.n108 27.1064
R645 VDPWR.n108 VDPWR.n71 27.1064
R646 VDPWR.n142 VDPWR.n141 27.1064
R647 VDPWR.n145 VDPWR.n142 27.1064
R648 VDPWR.n146 VDPWR.n145 27.1064
R649 VDPWR.n149 VDPWR.n146 27.1064
R650 VDPWR.n151 VDPWR.n149 27.1064
R651 VDPWR.n152 VDPWR.n151 27.1064
R652 VDPWR.n154 VDPWR.n152 27.1064
R653 VDPWR.n155 VDPWR.n154 27.1064
R654 VDPWR.n156 VDPWR.n155 27.1064
R655 VDPWR.n226 VDPWR.n224 27.1064
R656 VDPWR.n227 VDPWR.n226 27.1064
R657 VDPWR.n230 VDPWR.n227 27.1064
R658 VDPWR.n231 VDPWR.n230 27.1064
R659 VDPWR.n232 VDPWR.n231 27.1064
R660 VDPWR.n232 VDPWR.n14 27.1064
R661 VDPWR.n14 VDPWR.n13 27.1064
R662 VDPWR.n13 VDPWR.n2 27.1064
R663 VDPWR.n237 VDPWR.n2 27.1064
R664 VDPWR.n223 VDPWR.n15 27.1064
R665 VDPWR.n208 VDPWR.n15 27.1064
R666 VDPWR.n209 VDPWR.n208 27.1064
R667 VDPWR.n209 VDPWR.n207 27.1064
R668 VDPWR.n207 VDPWR.n206 27.1064
R669 VDPWR.n206 VDPWR.n23 27.1064
R670 VDPWR.n194 VDPWR.n23 27.1064
R671 VDPWR.n194 VDPWR.n193 27.1064
R672 VDPWR.n193 VDPWR.n192 27.1064
R673 VDPWR.n192 VDPWR.n34 27.1064
R674 VDPWR.n168 VDPWR.n167 27.1064
R675 VDPWR.n169 VDPWR.n168 27.1064
R676 VDPWR.n169 VDPWR.n162 27.1064
R677 VDPWR.n174 VDPWR.n162 27.1064
R678 VDPWR.n175 VDPWR.n174 27.1064
R679 VDPWR.n176 VDPWR.n175 27.1064
R680 VDPWR.n176 VDPWR.n160 27.1064
R681 VDPWR.n160 VDPWR.n40 27.1064
R682 VDPWR.n183 VDPWR.n40 27.1064
R683 VDPWR.n55 VDPWR.n49 20.0353
R684 VDPWR.n135 VDPWR.n55 20.0353
R685 VDPWR.n135 VDPWR.n54 20.0353
R686 VDPWR.n130 VDPWR.n54 20.0353
R687 VDPWR.n130 VDPWR.n57 20.0353
R688 VDPWR.n118 VDPWR.n57 20.0353
R689 VDPWR.n118 VDPWR.n65 20.0353
R690 VDPWR.n114 VDPWR.n65 20.0353
R691 VDPWR.n114 VDPWR.n67 20.0353
R692 VDPWR.n104 VDPWR.n67 20.0353
R693 VDPWR.n104 VDPWR.n75 20.0353
R694 VDPWR.n238 VDPWR.n1 20.0353
R695 VDPWR.n218 VDPWR.n1 20.0353
R696 VDPWR.n218 VDPWR.n18 20.0353
R697 VDPWR.n214 VDPWR.n18 20.0353
R698 VDPWR.n214 VDPWR.n20 20.0353
R699 VDPWR.n202 VDPWR.n20 20.0353
R700 VDPWR.n202 VDPWR.n28 20.0353
R701 VDPWR.n198 VDPWR.n28 20.0353
R702 VDPWR.n198 VDPWR.n30 20.0353
R703 VDPWR.n188 VDPWR.n30 20.0353
R704 VDPWR.n188 VDPWR.n38 20.0353
R705 VDPWR.n184 VDPWR.n38 20.0353
R706 VDPWR.n26 VDPWR.t1 11.8074
R707 VDPWR.t2 VDPWR.n25 11.8074
R708 VDPWR.n63 VDPWR.t5 11.8074
R709 VDPWR.t6 VDPWR.n62 11.8074
R710 VDPWR.n185 VDPWR.n184 9.3005
R711 VDPWR.n186 VDPWR.n38 9.3005
R712 VDPWR.n188 VDPWR.n187 9.3005
R713 VDPWR.n30 VDPWR.n29 9.3005
R714 VDPWR.n199 VDPWR.n198 9.3005
R715 VDPWR.n200 VDPWR.n28 9.3005
R716 VDPWR.n202 VDPWR.n201 9.3005
R717 VDPWR.n20 VDPWR.n19 9.3005
R718 VDPWR.n215 VDPWR.n214 9.3005
R719 VDPWR.n216 VDPWR.n18 9.3005
R720 VDPWR.n218 VDPWR.n217 9.3005
R721 VDPWR.n1 VDPWR.n0 9.3005
R722 VDPWR.n239 VDPWR.n238 9.3005
R723 VDPWR.n104 VDPWR.n103 9.3005
R724 VDPWR.n67 VDPWR.n66 9.3005
R725 VDPWR.n115 VDPWR.n114 9.3005
R726 VDPWR.n116 VDPWR.n65 9.3005
R727 VDPWR.n118 VDPWR.n117 9.3005
R728 VDPWR.n57 VDPWR.n56 9.3005
R729 VDPWR.n131 VDPWR.n130 9.3005
R730 VDPWR.n132 VDPWR.n54 9.3005
R731 VDPWR.n135 VDPWR.n134 9.3005
R732 VDPWR.n133 VDPWR.n55 9.3005
R733 VDPWR.n49 VDPWR.n39 9.3005
R734 VDPWR.n102 VDPWR.n75 4.81808
R735 VDPWR.n103 VDPWR.n102 2.29287
R736 VDPWR.n185 VDPWR.n39 0.26675
R737 VDPWR VDPWR.n239 0.133
R738 VDPWR.n239 VDPWR.n0 0.0455
R739 VDPWR.n217 VDPWR.n0 0.0455
R740 VDPWR.n217 VDPWR.n216 0.0455
R741 VDPWR.n216 VDPWR.n215 0.0455
R742 VDPWR.n215 VDPWR.n19 0.0455
R743 VDPWR.n201 VDPWR.n19 0.0455
R744 VDPWR.n201 VDPWR.n200 0.0455
R745 VDPWR.n200 VDPWR.n199 0.0455
R746 VDPWR.n199 VDPWR.n29 0.0455
R747 VDPWR.n187 VDPWR.n29 0.0455
R748 VDPWR.n187 VDPWR.n186 0.0455
R749 VDPWR.n186 VDPWR.n185 0.0455
R750 VDPWR.n133 VDPWR.n39 0.0455
R751 VDPWR.n134 VDPWR.n133 0.0455
R752 VDPWR.n134 VDPWR.n132 0.0455
R753 VDPWR.n132 VDPWR.n131 0.0455
R754 VDPWR.n131 VDPWR.n56 0.0455
R755 VDPWR.n117 VDPWR.n56 0.0455
R756 VDPWR.n117 VDPWR.n116 0.0455
R757 VDPWR.n116 VDPWR.n115 0.0455
R758 VDPWR.n115 VDPWR.n66 0.0455
R759 VDPWR.n103 VDPWR.n66 0.0455
R760 VGND.n154 VGND.n35 1118.26
R761 VGND.n142 VGND.n41 1118.26
R762 VGND.n147 VGND.n145 1118.26
R763 VGND.n61 VGND.n51 1118.26
R764 VGND.n93 VGND.n82 996.588
R765 VGND.n135 VGND.n46 996.588
R766 VGND.n131 VGND.n65 996.588
R767 VGND.n96 VGND.n84 996.588
R768 VGND.n206 VGND.n3 996.588
R769 VGND.n160 VGND.n25 996.588
R770 VGND.n202 VGND.n8 996.588
R771 VGND.n167 VGND.n27 996.588
R772 VGND.n83 VGND.n82 585
R773 VGND.n82 VGND.n81 585
R774 VGND.n102 VGND.n101 585
R775 VGND.n103 VGND.n102 585
R776 VGND.n78 VGND.n77 585
R777 VGND.n79 VGND.n78 585
R778 VGND.n110 VGND.n108 585
R779 VGND.n108 VGND.n107 585
R780 VGND.n109 VGND.n72 585
R781 VGND.n72 VGND.n71 585
R782 VGND.n117 VGND.n116 585
R783 VGND.n118 VGND.n117 585
R784 VGND.n73 VGND.n68 585
R785 VGND.n69 VGND.n68 585
R786 VGND.n124 VGND.n123 585
R787 VGND.n123 VGND.n122 585
R788 VGND.n48 VGND.n46 585
R789 VGND.n46 VGND.n44 585
R790 VGND.n136 VGND.n135 585
R791 VGND.n47 VGND.n45 585
R792 VGND.n133 VGND.n63 585
R793 VGND.n128 VGND.n63 585
R794 VGND.n129 VGND.n64 585
R795 VGND.n131 VGND.n130 585
R796 VGND.n65 VGND.n48 585
R797 VGND.n127 VGND.n65 585
R798 VGND.n125 VGND.n124 585
R799 VGND.n126 VGND.n125 585
R800 VGND.n73 VGND.n67 585
R801 VGND.n67 VGND.n66 585
R802 VGND.n116 VGND.n115 585
R803 VGND.n115 VGND.n114 585
R804 VGND.n109 VGND.n74 585
R805 VGND.n113 VGND.n74 585
R806 VGND.n111 VGND.n110 585
R807 VGND.n112 VGND.n111 585
R808 VGND.n77 VGND.n76 585
R809 VGND.n76 VGND.n75 585
R810 VGND.n101 VGND.n100 585
R811 VGND.n100 VGND.n99 585
R812 VGND.n84 VGND.n83 585
R813 VGND.n98 VGND.n84 585
R814 VGND.n97 VGND.n96 585
R815 VGND.n86 VGND.n85 585
R816 VGND.n90 VGND.n89 585
R817 VGND.n91 VGND.n88 585
R818 VGND.n94 VGND.n93 585
R819 VGND.n93 VGND.n92 585
R820 VGND.n8 VGND.n5 585
R821 VGND.n198 VGND.n8 585
R822 VGND.n196 VGND.n195 585
R823 VGND.n197 VGND.n196 585
R824 VGND.n16 VGND.n10 585
R825 VGND.n10 VGND.n9 585
R826 VGND.n187 VGND.n186 585
R827 VGND.n186 VGND.n185 585
R828 VGND.n180 VGND.n17 585
R829 VGND.n184 VGND.n17 585
R830 VGND.n182 VGND.n181 585
R831 VGND.n183 VGND.n182 585
R832 VGND.n20 VGND.n19 585
R833 VGND.n19 VGND.n18 585
R834 VGND.n172 VGND.n171 585
R835 VGND.n171 VGND.n170 585
R836 VGND.n27 VGND.n26 585
R837 VGND.n169 VGND.n27 585
R838 VGND.n167 VGND.n166 585
R839 VGND.n168 VGND.n167 585
R840 VGND.n29 VGND.n28 585
R841 VGND.n164 VGND.n163 585
R842 VGND.n162 VGND.n32 585
R843 VGND.n161 VGND.n160 585
R844 VGND.n26 VGND.n25 585
R845 VGND.n25 VGND.n24 585
R846 VGND.n173 VGND.n172 585
R847 VGND.n174 VGND.n173 585
R848 VGND.n21 VGND.n20 585
R849 VGND.n22 VGND.n21 585
R850 VGND.n181 VGND.n179 585
R851 VGND.n179 VGND.n178 585
R852 VGND.n180 VGND.n15 585
R853 VGND.n15 VGND.n14 585
R854 VGND.n188 VGND.n187 585
R855 VGND.n189 VGND.n188 585
R856 VGND.n16 VGND.n11 585
R857 VGND.n12 VGND.n11 585
R858 VGND.n195 VGND.n194 585
R859 VGND.n194 VGND.n193 585
R860 VGND.n5 VGND.n3 585
R861 VGND.n3 VGND.n1 585
R862 VGND.n207 VGND.n206 585
R863 VGND.n4 VGND.n2 585
R864 VGND.n204 VGND.n6 585
R865 VGND.n199 VGND.n6 585
R866 VGND.n200 VGND.n7 585
R867 VGND.n202 VGND.n201 585
R868 VGND.n145 VGND.n144 585
R869 VGND.n145 VGND.n38 585
R870 VGND.t8 VGND.n39 585
R871 VGND.n53 VGND.n39 585
R872 VGND.n51 VGND.n40 585
R873 VGND.n54 VGND.n51 585
R874 VGND.n62 VGND.n61 585
R875 VGND.n61 VGND.n60 585
R876 VGND.n59 VGND.n52 585
R877 VGND.n58 VGND.n57 585
R878 VGND.n56 VGND.n55 585
R879 VGND.n42 VGND.n41 585
R880 VGND.n142 VGND.n40 585
R881 VGND.n142 VGND.n141 585
R882 VGND.t8 VGND.n143 585
R883 VGND.n143 VGND.n34 585
R884 VGND.n144 VGND.n35 585
R885 VGND.n156 VGND.n35 585
R886 VGND.n155 VGND.n154 585
R887 VGND.n152 VGND.n36 585
R888 VGND.n151 VGND.n30 585
R889 VGND.n151 VGND.n150 585
R890 VGND.n149 VGND.n37 585
R891 VGND.n148 VGND.n147 585
R892 VGND.n93 VGND.n88 417.176
R893 VGND.n89 VGND.n86 417.176
R894 VGND.n123 VGND.n46 417.176
R895 VGND.n123 VGND.n68 417.176
R896 VGND.n117 VGND.n68 417.176
R897 VGND.n117 VGND.n72 417.176
R898 VGND.n108 VGND.n72 417.176
R899 VGND.n108 VGND.n78 417.176
R900 VGND.n102 VGND.n78 417.176
R901 VGND.n102 VGND.n82 417.176
R902 VGND.n63 VGND.n47 417.176
R903 VGND.n64 VGND.n63 417.176
R904 VGND.n125 VGND.n65 417.176
R905 VGND.n125 VGND.n67 417.176
R906 VGND.n115 VGND.n67 417.176
R907 VGND.n115 VGND.n74 417.176
R908 VGND.n111 VGND.n74 417.176
R909 VGND.n111 VGND.n76 417.176
R910 VGND.n100 VGND.n76 417.176
R911 VGND.n100 VGND.n84 417.176
R912 VGND.n152 VGND.n151 417.176
R913 VGND.n151 VGND.n37 417.176
R914 VGND.n143 VGND.n35 417.176
R915 VGND.n143 VGND.n142 417.176
R916 VGND.n57 VGND.n56 417.176
R917 VGND.n61 VGND.n52 417.176
R918 VGND.n145 VGND.n39 417.176
R919 VGND.n51 VGND.n39 417.176
R920 VGND.n6 VGND.n4 417.176
R921 VGND.n7 VGND.n6 417.176
R922 VGND.n194 VGND.n3 417.176
R923 VGND.n194 VGND.n11 417.176
R924 VGND.n188 VGND.n11 417.176
R925 VGND.n188 VGND.n15 417.176
R926 VGND.n179 VGND.n15 417.176
R927 VGND.n179 VGND.n21 417.176
R928 VGND.n173 VGND.n21 417.176
R929 VGND.n173 VGND.n25 417.176
R930 VGND.n164 VGND.n32 417.176
R931 VGND.n167 VGND.n29 417.176
R932 VGND.n196 VGND.n8 417.176
R933 VGND.n196 VGND.n10 417.176
R934 VGND.n186 VGND.n10 417.176
R935 VGND.n186 VGND.n17 417.176
R936 VGND.n182 VGND.n17 417.176
R937 VGND.n182 VGND.n19 417.176
R938 VGND.n171 VGND.n19 417.176
R939 VGND.n171 VGND.n27 417.176
R940 VGND.n144 VGND.n30 390.555
R941 VGND.n62 VGND.n40 390.555
R942 VGND.n204 VGND.n5 315.31
R943 VGND.n166 VGND.n26 315.31
R944 VGND.n166 VGND.n30 315.31
R945 VGND.n133 VGND.n62 315.31
R946 VGND.n133 VGND.n48 315.31
R947 VGND.n94 VGND.n83 315.31
R948 VGND.n195 VGND.n5 257.981
R949 VGND.n187 VGND.n16 257.981
R950 VGND.n181 VGND.n20 257.981
R951 VGND.n172 VGND.n26 257.981
R952 VGND.n144 VGND.t8 257.981
R953 VGND.t8 VGND.n40 257.981
R954 VGND.n124 VGND.n48 257.981
R955 VGND.n116 VGND.n73 257.981
R956 VGND.n110 VGND.n77 257.981
R957 VGND.n101 VGND.n83 257.981
R958 VGND.n180 VGND.t1 232.899
R959 VGND.t2 VGND.n180 232.899
R960 VGND.n109 VGND.t5 232.899
R961 VGND.t6 VGND.n109 232.899
R962 VGND.n134 VGND.n133 215.619
R963 VGND.n133 VGND.n132 215.619
R964 VGND.n95 VGND.n94 215.619
R965 VGND.n94 VGND.n87 215.619
R966 VGND.n166 VGND.n165 215.619
R967 VGND.n166 VGND.n31 215.619
R968 VGND.n205 VGND.n204 215.619
R969 VGND.n204 VGND.n203 215.619
R970 VGND.n62 VGND.n50 215.619
R971 VGND.n62 VGND.n49 215.619
R972 VGND.n153 VGND.n30 215.619
R973 VGND.n146 VGND.n30 215.619
R974 VGND.n16 VGND.t0 182.737
R975 VGND.t3 VGND.n20 182.737
R976 VGND.n73 VGND.t4 182.737
R977 VGND.t7 VGND.n77 182.737
R978 VGND.n135 VGND.n134 153.763
R979 VGND.n132 VGND.n64 153.763
R980 VGND.n95 VGND.n86 153.763
R981 VGND.n88 VGND.n87 153.763
R982 VGND.n89 VGND.n87 153.763
R983 VGND.n96 VGND.n95 153.763
R984 VGND.n134 VGND.n47 153.763
R985 VGND.n132 VGND.n131 153.763
R986 VGND.n165 VGND.n29 153.763
R987 VGND.n32 VGND.n31 153.763
R988 VGND.n206 VGND.n205 153.763
R989 VGND.n203 VGND.n7 153.763
R990 VGND.n52 VGND.n50 153.763
R991 VGND.n56 VGND.n49 153.763
R992 VGND.n154 VGND.n153 153.763
R993 VGND.n146 VGND.n37 153.763
R994 VGND.n153 VGND.n152 153.763
R995 VGND.n147 VGND.n146 153.763
R996 VGND.n49 VGND.n41 153.763
R997 VGND.n57 VGND.n50 153.763
R998 VGND.n205 VGND.n4 153.763
R999 VGND.n203 VGND.n202 153.763
R1000 VGND.n160 VGND.n31 153.763
R1001 VGND.n165 VGND.n164 153.763
R1002 VGND.n33 VGND.t9 133.562
R1003 VGND.n195 VGND.t0 75.2448
R1004 VGND.n172 VGND.t3 75.2448
R1005 VGND.n124 VGND.t4 75.2448
R1006 VGND.n101 VGND.t7 75.2448
R1007 VGND.n156 VGND.n155 72.6593
R1008 VGND.n141 VGND.n42 72.6593
R1009 VGND.n148 VGND.n38 72.6593
R1010 VGND.n60 VGND.n54 72.6593
R1011 VGND.n130 VGND.n127 64.7534
R1012 VGND.n98 VGND.n97 64.7534
R1013 VGND.n201 VGND.n198 64.7534
R1014 VGND.n169 VGND.n168 64.7534
R1015 VGND.n92 VGND.n80 38.6583
R1016 VGND.n137 VGND.n136 33.8174
R1017 VGND.n208 VGND.n207 33.8174
R1018 VGND.n161 VGND.n159 33.8174
R1019 VGND.n136 VGND.n45 27.1064
R1020 VGND.n128 VGND.n45 27.1064
R1021 VGND.n129 VGND.n128 27.1064
R1022 VGND.n130 VGND.n129 27.1064
R1023 VGND.n127 VGND.n126 27.1064
R1024 VGND.n126 VGND.n66 27.1064
R1025 VGND.n114 VGND.n66 27.1064
R1026 VGND.n114 VGND.n113 27.1064
R1027 VGND.n113 VGND.n112 27.1064
R1028 VGND.n112 VGND.n75 27.1064
R1029 VGND.n99 VGND.n75 27.1064
R1030 VGND.n99 VGND.n98 27.1064
R1031 VGND.n92 VGND.n91 27.1064
R1032 VGND.n91 VGND.n90 27.1064
R1033 VGND.n90 VGND.n85 27.1064
R1034 VGND.n97 VGND.n85 27.1064
R1035 VGND.n155 VGND.n36 27.1064
R1036 VGND.n150 VGND.n36 27.1064
R1037 VGND.n150 VGND.n149 27.1064
R1038 VGND.n149 VGND.n148 27.1064
R1039 VGND.n156 VGND.n34 27.1064
R1040 VGND.n141 VGND.n34 27.1064
R1041 VGND.n55 VGND.n42 27.1064
R1042 VGND.n58 VGND.n55 27.1064
R1043 VGND.n59 VGND.n58 27.1064
R1044 VGND.n60 VGND.n59 27.1064
R1045 VGND.n53 VGND.n38 27.1064
R1046 VGND.n54 VGND.n53 27.1064
R1047 VGND.n207 VGND.n2 27.1064
R1048 VGND.n199 VGND.n2 27.1064
R1049 VGND.n200 VGND.n199 27.1064
R1050 VGND.n201 VGND.n200 27.1064
R1051 VGND.n162 VGND.n161 27.1064
R1052 VGND.n163 VGND.n162 27.1064
R1053 VGND.n163 VGND.n28 27.1064
R1054 VGND.n168 VGND.n28 27.1064
R1055 VGND.n198 VGND.n197 27.1064
R1056 VGND.n197 VGND.n9 27.1064
R1057 VGND.n185 VGND.n9 27.1064
R1058 VGND.n185 VGND.n184 27.1064
R1059 VGND.n184 VGND.n183 27.1064
R1060 VGND.n183 VGND.n18 27.1064
R1061 VGND.n170 VGND.n18 27.1064
R1062 VGND.n170 VGND.n169 27.1064
R1063 VGND.n187 VGND.t1 25.0819
R1064 VGND.n181 VGND.t2 25.0819
R1065 VGND.n116 VGND.t5 25.0819
R1066 VGND.n110 VGND.t6 25.0819
R1067 VGND.n137 VGND.n44 20.0353
R1068 VGND.n122 VGND.n44 20.0353
R1069 VGND.n122 VGND.n69 20.0353
R1070 VGND.n118 VGND.n69 20.0353
R1071 VGND.n118 VGND.n71 20.0353
R1072 VGND.n107 VGND.n71 20.0353
R1073 VGND.n107 VGND.n79 20.0353
R1074 VGND.n103 VGND.n79 20.0353
R1075 VGND.n103 VGND.n81 20.0353
R1076 VGND.n208 VGND.n1 20.0353
R1077 VGND.n193 VGND.n1 20.0353
R1078 VGND.n193 VGND.n12 20.0353
R1079 VGND.n189 VGND.n12 20.0353
R1080 VGND.n189 VGND.n14 20.0353
R1081 VGND.n178 VGND.n14 20.0353
R1082 VGND.n178 VGND.n22 20.0353
R1083 VGND.n174 VGND.n22 20.0353
R1084 VGND.n174 VGND.n24 20.0353
R1085 VGND.n159 VGND.n24 20.0353
R1086 VGND.n24 VGND.n23 9.3005
R1087 VGND.n159 VGND.n158 9.3005
R1088 VGND.n209 VGND.n208 9.3005
R1089 VGND.n1 VGND.n0 9.3005
R1090 VGND.n193 VGND.n192 9.3005
R1091 VGND.n191 VGND.n12 9.3005
R1092 VGND.n190 VGND.n189 9.3005
R1093 VGND.n14 VGND.n13 9.3005
R1094 VGND.n178 VGND.n177 9.3005
R1095 VGND.n176 VGND.n22 9.3005
R1096 VGND.n175 VGND.n174 9.3005
R1097 VGND.n141 VGND.n140 9.3005
R1098 VGND.n139 VGND.n34 9.3005
R1099 VGND.n157 VGND.n156 9.3005
R1100 VGND.n138 VGND.n137 9.3005
R1101 VGND.n44 VGND.n43 9.3005
R1102 VGND.n122 VGND.n121 9.3005
R1103 VGND.n120 VGND.n69 9.3005
R1104 VGND.n119 VGND.n118 9.3005
R1105 VGND.n71 VGND.n70 9.3005
R1106 VGND.n107 VGND.n106 9.3005
R1107 VGND.n105 VGND.n79 9.3005
R1108 VGND.n104 VGND.n103 9.3005
R1109 VGND.n81 VGND.n80 4.81808
R1110 VGND.n104 VGND.n80 2.29287
R1111 VGND VGND.n209 0.178
R1112 VGND.n158 VGND.n157 0.133625
R1113 VGND.n140 VGND.n138 0.133625
R1114 VGND.n209 VGND.n0 0.0455
R1115 VGND.n192 VGND.n0 0.0455
R1116 VGND.n192 VGND.n191 0.0455
R1117 VGND.n191 VGND.n190 0.0455
R1118 VGND.n190 VGND.n13 0.0455
R1119 VGND.n177 VGND.n13 0.0455
R1120 VGND.n177 VGND.n176 0.0455
R1121 VGND.n176 VGND.n175 0.0455
R1122 VGND.n175 VGND.n23 0.0455
R1123 VGND.n158 VGND.n23 0.0455
R1124 VGND.n140 VGND.n139 0.0455
R1125 VGND.n138 VGND.n43 0.0455
R1126 VGND.n121 VGND.n43 0.0455
R1127 VGND.n121 VGND.n120 0.0455
R1128 VGND.n120 VGND.n119 0.0455
R1129 VGND.n119 VGND.n70 0.0455
R1130 VGND.n106 VGND.n70 0.0455
R1131 VGND.n106 VGND.n105 0.0455
R1132 VGND.n105 VGND.n104 0.0455
R1133 VGND.n139 VGND.n33 0.028625
R1134 VGND.n157 VGND.n33 0.017375
R1135 ELAD1_TGA_0.B.n108 ELAD1_TGA_0.B.n107 585
R1136 ELAD1_TGA_0.B.n81 ELAD1_TGA_0.B.n80 585
R1137 ELAD1_TGA_0.B.n98 ELAD1_TGA_0.B.n97 585
R1138 ELAD1_TGA_0.B.n96 ELAD1_TGA_0.B.n86 585
R1139 ELAD1_TGA_0.B.n67 ELAD1_TGA_0.B.n66 585
R1140 ELAD1_TGA_0.B.n40 ELAD1_TGA_0.B.n39 585
R1141 ELAD1_TGA_0.B.n57 ELAD1_TGA_0.B.n56 585
R1142 ELAD1_TGA_0.B.n55 ELAD1_TGA_0.B.n45 585
R1143 ELAD1_TGA_0.B.n144 ELAD1_TGA_0.B.n143 585
R1144 ELAD1_TGA_0.B.n143 ELAD1_TGA_0.B.n142 585
R1145 ELAD1_TGA_0.B.n109 ELAD1_TGA_0.B.n108 571.606
R1146 ELAD1_TGA_0.B.n96 ELAD1_TGA_0.B.n95 571.606
R1147 ELAD1_TGA_0.B.n68 ELAD1_TGA_0.B.n67 571.606
R1148 ELAD1_TGA_0.B.n55 ELAD1_TGA_0.B.n54 571.606
R1149 ELAD1_TGA_0.B.n184 ELAD1_TGA_0.B.n155 285.877
R1150 ELAD1_TGA_0.B.n175 ELAD1_TGA_0.B.n155 285.877
R1151 ELAD1_TGA_0.B.n173 ELAD1_TGA_0.B.n155 285.877
R1152 ELAD1_TGA_0.B.n163 ELAD1_TGA_0.B.n155 285.877
R1153 ELAD1_TGA_0.B.n32 ELAD1_TGA_0.B.n31 285.877
R1154 ELAD1_TGA_0.B.n31 ELAD1_TGA_0.B.n4 285.877
R1155 ELAD1_TGA_0.B.n31 ELAD1_TGA_0.B.n5 285.877
R1156 ELAD1_TGA_0.B.n31 ELAD1_TGA_0.B.n30 285.877
R1157 ELAD1_TGA_0.B.n143 ELAD1_TGA_0.B.n116 285.877
R1158 ELAD1_TGA_0.B.n143 ELAD1_TGA_0.B.n117 285.877
R1159 ELAD1_TGA_0.B.n143 ELAD1_TGA_0.B.n118 285.877
R1160 ELAD1_TGA_0.B.n108 ELAD1_TGA_0.B.n80 236.4
R1161 ELAD1_TGA_0.B.n97 ELAD1_TGA_0.B.n96 236.4
R1162 ELAD1_TGA_0.B.n67 ELAD1_TGA_0.B.n39 236.4
R1163 ELAD1_TGA_0.B.n56 ELAD1_TGA_0.B.n55 236.4
R1164 ELAD1_TGA_0.B.n152 ELAD1_TGA_0.B.t3 136.989
R1165 ELAD1_TGA_0.B.n147 ELAD1_TGA_0.B.t0 136.888
R1166 ELAD1_TGA_0.B.n76 ELAD1_TGA_0.B.t16 136.72
R1167 ELAD1_TGA_0.B.t12 ELAD1_TGA_0.B.n80 118.201
R1168 ELAD1_TGA_0.B.n97 ELAD1_TGA_0.B.t12 118.201
R1169 ELAD1_TGA_0.B.t15 ELAD1_TGA_0.B.n39 118.201
R1170 ELAD1_TGA_0.B.n56 ELAD1_TGA_0.B.t15 118.201
R1171 ELAD1_TGA_0.B.n151 ELAD1_TGA_0.B.n150 103.132
R1172 ELAD1_TGA_0.B.n73 ELAD1_TGA_0.B.n72 102.648
R1173 ELAD1_TGA_0.B.n75 ELAD1_TGA_0.B.n74 102.648
R1174 ELAD1_TGA_0.B.n72 ELAD1_TGA_0.B.t6 30.0005
R1175 ELAD1_TGA_0.B.n72 ELAD1_TGA_0.B.t7 30.0005
R1176 ELAD1_TGA_0.B.n74 ELAD1_TGA_0.B.t4 30.0005
R1177 ELAD1_TGA_0.B.n74 ELAD1_TGA_0.B.t5 30.0005
R1178 ELAD1_TGA_0.B.n150 ELAD1_TGA_0.B.t1 30.0005
R1179 ELAD1_TGA_0.B.n150 ELAD1_TGA_0.B.t2 30.0005
R1180 ELAD1_TGA_0.B.n183 ELAD1_TGA_0.B.n156 27.1064
R1181 ELAD1_TGA_0.B.n176 ELAD1_TGA_0.B.n174 27.1064
R1182 ELAD1_TGA_0.B.n172 ELAD1_TGA_0.B.n161 27.1064
R1183 ELAD1_TGA_0.B.n107 ELAD1_TGA_0.B.n79 27.1064
R1184 ELAD1_TGA_0.B.n107 ELAD1_TGA_0.B.n81 27.1064
R1185 ELAD1_TGA_0.B.n98 ELAD1_TGA_0.B.n81 27.1064
R1186 ELAD1_TGA_0.B.n98 ELAD1_TGA_0.B.n86 27.1064
R1187 ELAD1_TGA_0.B.n94 ELAD1_TGA_0.B.n86 27.1064
R1188 ELAD1_TGA_0.B.n66 ELAD1_TGA_0.B.n38 27.1064
R1189 ELAD1_TGA_0.B.n66 ELAD1_TGA_0.B.n40 27.1064
R1190 ELAD1_TGA_0.B.n57 ELAD1_TGA_0.B.n40 27.1064
R1191 ELAD1_TGA_0.B.n57 ELAD1_TGA_0.B.n45 27.1064
R1192 ELAD1_TGA_0.B.n53 ELAD1_TGA_0.B.n45 27.1064
R1193 ELAD1_TGA_0.B.n14 ELAD1_TGA_0.B.n3 27.1064
R1194 ELAD1_TGA_0.B.n18 ELAD1_TGA_0.B.n17 27.1064
R1195 ELAD1_TGA_0.B.n24 ELAD1_TGA_0.B.n6 27.1064
R1196 ELAD1_TGA_0.B.n144 ELAD1_TGA_0.B.n115 27.1064
R1197 ELAD1_TGA_0.B.n135 ELAD1_TGA_0.B.n134 27.1064
R1198 ELAD1_TGA_0.B.n142 ELAD1_TGA_0.B.n120 27.1064
R1199 ELAD1_TGA_0.B.n142 ELAD1_TGA_0.B.n119 27.1064
R1200 ELAD1_TGA_0.B.n95 ELAD1_TGA_0.B.n87 24.8567
R1201 ELAD1_TGA_0.B.n54 ELAD1_TGA_0.B.n46 24.8567
R1202 ELAD1_TGA_0.B.n110 ELAD1_TGA_0.B.n109 24.8327
R1203 ELAD1_TGA_0.B.n69 ELAD1_TGA_0.B.n68 24.8327
R1204 ELAD1_TGA_0.B.n164 ELAD1_TGA_0.B.n163 22.5711
R1205 ELAD1_TGA_0.B.n30 ELAD1_TGA_0.B.n29 22.5711
R1206 ELAD1_TGA_0.B.n123 ELAD1_TGA_0.B.n116 22.5711
R1207 ELAD1_TGA_0.B.n185 ELAD1_TGA_0.B.n184 22.5471
R1208 ELAD1_TGA_0.B.n33 ELAD1_TGA_0.B.n32 22.5471
R1209 ELAD1_TGA_0.B.n155 ELAD1_TGA_0.B.t10 16.4172
R1210 ELAD1_TGA_0.B.n155 ELAD1_TGA_0.B.t11 16.4172
R1211 ELAD1_TGA_0.B.n31 ELAD1_TGA_0.B.t13 16.4172
R1212 ELAD1_TGA_0.B.n31 ELAD1_TGA_0.B.t14 16.4172
R1213 ELAD1_TGA_0.B.n143 ELAD1_TGA_0.B.t8 16.4172
R1214 ELAD1_TGA_0.B.n143 ELAD1_TGA_0.B.t9 16.4172
R1215 ELAD1_TGA_0.B.n175 ELAD1_TGA_0.B.n156 13.2471
R1216 ELAD1_TGA_0.B.n174 ELAD1_TGA_0.B.n173 13.2471
R1217 ELAD1_TGA_0.B.n163 ELAD1_TGA_0.B.n161 13.2471
R1218 ELAD1_TGA_0.B.n184 ELAD1_TGA_0.B.n183 13.2471
R1219 ELAD1_TGA_0.B.n176 ELAD1_TGA_0.B.n175 13.2471
R1220 ELAD1_TGA_0.B.n173 ELAD1_TGA_0.B.n172 13.2471
R1221 ELAD1_TGA_0.B.n32 ELAD1_TGA_0.B.n3 13.2471
R1222 ELAD1_TGA_0.B.n18 ELAD1_TGA_0.B.n4 13.2471
R1223 ELAD1_TGA_0.B.n24 ELAD1_TGA_0.B.n5 13.2471
R1224 ELAD1_TGA_0.B.n14 ELAD1_TGA_0.B.n4 13.2471
R1225 ELAD1_TGA_0.B.n17 ELAD1_TGA_0.B.n5 13.2471
R1226 ELAD1_TGA_0.B.n30 ELAD1_TGA_0.B.n6 13.2471
R1227 ELAD1_TGA_0.B.n134 ELAD1_TGA_0.B.n117 13.2471
R1228 ELAD1_TGA_0.B.n120 ELAD1_TGA_0.B.n118 13.2471
R1229 ELAD1_TGA_0.B.n119 ELAD1_TGA_0.B.n116 13.2471
R1230 ELAD1_TGA_0.B.n117 ELAD1_TGA_0.B.n115 13.2471
R1231 ELAD1_TGA_0.B.n135 ELAD1_TGA_0.B.n118 13.2471
R1232 ELAD1_TGA_0.B.n109 ELAD1_TGA_0.B.n79 11.0627
R1233 ELAD1_TGA_0.B.n95 ELAD1_TGA_0.B.n94 11.0627
R1234 ELAD1_TGA_0.B.n68 ELAD1_TGA_0.B.n38 11.0627
R1235 ELAD1_TGA_0.B.n54 ELAD1_TGA_0.B.n53 11.0627
R1236 ELAD1_TGA_0.B.n183 ELAD1_TGA_0.B.n182 9.3005
R1237 ELAD1_TGA_0.B.n157 ELAD1_TGA_0.B.n156 9.3005
R1238 ELAD1_TGA_0.B.n177 ELAD1_TGA_0.B.n176 9.3005
R1239 ELAD1_TGA_0.B.n174 ELAD1_TGA_0.B.n160 9.3005
R1240 ELAD1_TGA_0.B.n172 ELAD1_TGA_0.B.n171 9.3005
R1241 ELAD1_TGA_0.B.n165 ELAD1_TGA_0.B.n161 9.3005
R1242 ELAD1_TGA_0.B.n83 ELAD1_TGA_0.B.n79 9.3005
R1243 ELAD1_TGA_0.B.n107 ELAD1_TGA_0.B.n106 9.3005
R1244 ELAD1_TGA_0.B.n100 ELAD1_TGA_0.B.n81 9.3005
R1245 ELAD1_TGA_0.B.n99 ELAD1_TGA_0.B.n98 9.3005
R1246 ELAD1_TGA_0.B.n88 ELAD1_TGA_0.B.n86 9.3005
R1247 ELAD1_TGA_0.B.n94 ELAD1_TGA_0.B.n93 9.3005
R1248 ELAD1_TGA_0.B.n42 ELAD1_TGA_0.B.n38 9.3005
R1249 ELAD1_TGA_0.B.n66 ELAD1_TGA_0.B.n65 9.3005
R1250 ELAD1_TGA_0.B.n59 ELAD1_TGA_0.B.n40 9.3005
R1251 ELAD1_TGA_0.B.n58 ELAD1_TGA_0.B.n57 9.3005
R1252 ELAD1_TGA_0.B.n47 ELAD1_TGA_0.B.n45 9.3005
R1253 ELAD1_TGA_0.B.n53 ELAD1_TGA_0.B.n52 9.3005
R1254 ELAD1_TGA_0.B.n11 ELAD1_TGA_0.B.n3 9.3005
R1255 ELAD1_TGA_0.B.n15 ELAD1_TGA_0.B.n14 9.3005
R1256 ELAD1_TGA_0.B.n19 ELAD1_TGA_0.B.n18 9.3005
R1257 ELAD1_TGA_0.B.n17 ELAD1_TGA_0.B.n9 9.3005
R1258 ELAD1_TGA_0.B.n25 ELAD1_TGA_0.B.n24 9.3005
R1259 ELAD1_TGA_0.B.n7 ELAD1_TGA_0.B.n6 9.3005
R1260 ELAD1_TGA_0.B.n124 ELAD1_TGA_0.B.n119 9.3005
R1261 ELAD1_TGA_0.B.n142 ELAD1_TGA_0.B.n141 9.3005
R1262 ELAD1_TGA_0.B.n122 ELAD1_TGA_0.B.n120 9.3005
R1263 ELAD1_TGA_0.B.n136 ELAD1_TGA_0.B.n135 9.3005
R1264 ELAD1_TGA_0.B.n134 ELAD1_TGA_0.B.n133 9.3005
R1265 ELAD1_TGA_0.B.n130 ELAD1_TGA_0.B.n115 9.3005
R1266 ELAD1_TGA_0.B.n145 ELAD1_TGA_0.B.n144 9.3005
R1267 ELAD1_TGA_0.B.n188 ELAD1_TGA_0.B.n187 6.31881
R1268 ELAD1_TGA_0.B.n91 ELAD1_TGA_0.B.n87 4.65435
R1269 ELAD1_TGA_0.B.n50 ELAD1_TGA_0.B.n46 4.65435
R1270 ELAD1_TGA_0.B.n29 ELAD1_TGA_0.B.n28 4.65435
R1271 ELAD1_TGA_0.B.n126 ELAD1_TGA_0.B.n123 4.65435
R1272 ELAD1_TGA_0.B.n167 ELAD1_TGA_0.B.n164 4.61815
R1273 ELAD1_TGA_0.B.n191 ELAD1_TGA_0.B.n190 4.57983
R1274 ELAD1_TGA_0.B.n186 ELAD1_TGA_0.B.n185 4.54377
R1275 ELAD1_TGA_0.B.n111 ELAD1_TGA_0.B.n110 4.54377
R1276 ELAD1_TGA_0.B.n70 ELAD1_TGA_0.B.n69 4.54377
R1277 ELAD1_TGA_0.B.n34 ELAD1_TGA_0.B.n33 4.54377
R1278 ELAD1_TGA_0.B.n146 ELAD1_TGA_0.B.n145 4.54377
R1279 ELAD1_TGA_0.B.n154 ELAD1_TGA_0.B.n153 4.5005
R1280 ELAD1_TGA_0.B.n181 ELAD1_TGA_0.B.n180 4.5005
R1281 ELAD1_TGA_0.B.n179 ELAD1_TGA_0.B.n178 4.5005
R1282 ELAD1_TGA_0.B.n159 ELAD1_TGA_0.B.n158 4.5005
R1283 ELAD1_TGA_0.B.n170 ELAD1_TGA_0.B.n169 4.5005
R1284 ELAD1_TGA_0.B.n168 ELAD1_TGA_0.B.n162 4.5005
R1285 ELAD1_TGA_0.B.n167 ELAD1_TGA_0.B.n166 4.5005
R1286 ELAD1_TGA_0.B.n78 ELAD1_TGA_0.B.n77 4.5005
R1287 ELAD1_TGA_0.B.n105 ELAD1_TGA_0.B.n104 4.5005
R1288 ELAD1_TGA_0.B.n103 ELAD1_TGA_0.B.n82 4.5005
R1289 ELAD1_TGA_0.B.n102 ELAD1_TGA_0.B.n101 4.5005
R1290 ELAD1_TGA_0.B.n85 ELAD1_TGA_0.B.n84 4.5005
R1291 ELAD1_TGA_0.B.n90 ELAD1_TGA_0.B.n89 4.5005
R1292 ELAD1_TGA_0.B.n92 ELAD1_TGA_0.B.n91 4.5005
R1293 ELAD1_TGA_0.B.n189 ELAD1_TGA_0.B.n0 4.5005
R1294 ELAD1_TGA_0.B.n37 ELAD1_TGA_0.B.n36 4.5005
R1295 ELAD1_TGA_0.B.n64 ELAD1_TGA_0.B.n63 4.5005
R1296 ELAD1_TGA_0.B.n62 ELAD1_TGA_0.B.n41 4.5005
R1297 ELAD1_TGA_0.B.n61 ELAD1_TGA_0.B.n60 4.5005
R1298 ELAD1_TGA_0.B.n44 ELAD1_TGA_0.B.n43 4.5005
R1299 ELAD1_TGA_0.B.n49 ELAD1_TGA_0.B.n48 4.5005
R1300 ELAD1_TGA_0.B.n51 ELAD1_TGA_0.B.n50 4.5005
R1301 ELAD1_TGA_0.B.n2 ELAD1_TGA_0.B.n1 4.5005
R1302 ELAD1_TGA_0.B.n13 ELAD1_TGA_0.B.n12 4.5005
R1303 ELAD1_TGA_0.B.n16 ELAD1_TGA_0.B.n10 4.5005
R1304 ELAD1_TGA_0.B.n21 ELAD1_TGA_0.B.n20 4.5005
R1305 ELAD1_TGA_0.B.n23 ELAD1_TGA_0.B.n22 4.5005
R1306 ELAD1_TGA_0.B.n26 ELAD1_TGA_0.B.n8 4.5005
R1307 ELAD1_TGA_0.B.n28 ELAD1_TGA_0.B.n27 4.5005
R1308 ELAD1_TGA_0.B.n147 ELAD1_TGA_0.B.n112 4.5005
R1309 ELAD1_TGA_0.B.n149 ELAD1_TGA_0.B.n148 4.5005
R1310 ELAD1_TGA_0.B.n126 ELAD1_TGA_0.B.n125 4.5005
R1311 ELAD1_TGA_0.B.n127 ELAD1_TGA_0.B.n121 4.5005
R1312 ELAD1_TGA_0.B.n140 ELAD1_TGA_0.B.n139 4.5005
R1313 ELAD1_TGA_0.B.n138 ELAD1_TGA_0.B.n137 4.5005
R1314 ELAD1_TGA_0.B.n129 ELAD1_TGA_0.B.n128 4.5005
R1315 ELAD1_TGA_0.B.n132 ELAD1_TGA_0.B.n131 4.5005
R1316 ELAD1_TGA_0.B.n114 ELAD1_TGA_0.B.n113 4.5005
R1317 ELAD1_TGA_0.B.n73 ELAD1_TGA_0.B.n71 3.65487
R1318 ELAD1_TGA_0.B.n35 ELAD1_TGA_0.B.n34 3.28132
R1319 ELAD1_TGA_0.B.n71 ELAD1_TGA_0.B.n35 3.09623
R1320 ELAD1_TGA_0.B.n76 ELAD1_TGA_0.B.n75 2.85437
R1321 ELAD1_TGA_0.B.n152 ELAD1_TGA_0.B.n151 2.64442
R1322 ELAD1_TGA_0.B.n148 ELAD1_TGA_0.B.n146 1.43413
R1323 ELAD1_TGA_0.B.n71 ELAD1_TGA_0.B.n70 1.10277
R1324 ELAD1_TGA_0.B.n35 ELAD1_TGA_0.B.n0 0.802653
R1325 ELAD1_TGA_0.B.n188 ELAD1_TGA_0.B.n111 0.799204
R1326 ELAD1_TGA_0.B.n187 ELAD1_TGA_0.B.n186 0.774317
R1327 ELAD1_TGA_0.B.n190 ELAD1_TGA_0.B.n76 0.763612
R1328 ELAD1_TGA_0.B.n112 ELAD1_TGA_0.B 0.680788
R1329 ELAD1_TGA_0.B.n75 ELAD1_TGA_0.B.n73 0.6255
R1330 ELAD1_TGA_0.B.n187 ELAD1_TGA_0.B.n152 0.593043
R1331 ELAD1_TGA_0.B.n151 ELAD1_TGA_0.B.n149 0.41323
R1332 ELAD1_TGA_0.B ELAD1_TGA_0.B.n191 0.291365
R1333 ELAD1_TGA_0.B.n166 ELAD1_TGA_0.B.n162 0.154346
R1334 ELAD1_TGA_0.B.n111 ELAD1_TGA_0.B.n77 0.154346
R1335 ELAD1_TGA_0.B.n104 ELAD1_TGA_0.B.n77 0.154346
R1336 ELAD1_TGA_0.B.n104 ELAD1_TGA_0.B.n103 0.154346
R1337 ELAD1_TGA_0.B.n103 ELAD1_TGA_0.B.n102 0.154346
R1338 ELAD1_TGA_0.B.n102 ELAD1_TGA_0.B.n84 0.154346
R1339 ELAD1_TGA_0.B.n90 ELAD1_TGA_0.B.n84 0.154346
R1340 ELAD1_TGA_0.B.n91 ELAD1_TGA_0.B.n90 0.154346
R1341 ELAD1_TGA_0.B.n92 ELAD1_TGA_0.B.n89 0.154346
R1342 ELAD1_TGA_0.B.n70 ELAD1_TGA_0.B.n36 0.154346
R1343 ELAD1_TGA_0.B.n63 ELAD1_TGA_0.B.n36 0.154346
R1344 ELAD1_TGA_0.B.n63 ELAD1_TGA_0.B.n62 0.154346
R1345 ELAD1_TGA_0.B.n62 ELAD1_TGA_0.B.n61 0.154346
R1346 ELAD1_TGA_0.B.n61 ELAD1_TGA_0.B.n43 0.154346
R1347 ELAD1_TGA_0.B.n49 ELAD1_TGA_0.B.n43 0.154346
R1348 ELAD1_TGA_0.B.n50 ELAD1_TGA_0.B.n49 0.154346
R1349 ELAD1_TGA_0.B.n51 ELAD1_TGA_0.B.n48 0.154346
R1350 ELAD1_TGA_0.B.n191 ELAD1_TGA_0.B.n0 0.154346
R1351 ELAD1_TGA_0.B.n34 ELAD1_TGA_0.B.n1 0.154346
R1352 ELAD1_TGA_0.B.n12 ELAD1_TGA_0.B.n1 0.154346
R1353 ELAD1_TGA_0.B.n12 ELAD1_TGA_0.B.n10 0.154346
R1354 ELAD1_TGA_0.B.n21 ELAD1_TGA_0.B.n10 0.154346
R1355 ELAD1_TGA_0.B.n22 ELAD1_TGA_0.B.n21 0.154346
R1356 ELAD1_TGA_0.B.n22 ELAD1_TGA_0.B.n8 0.154346
R1357 ELAD1_TGA_0.B.n28 ELAD1_TGA_0.B.n8 0.154346
R1358 ELAD1_TGA_0.B.n27 ELAD1_TGA_0.B.n26 0.154346
R1359 ELAD1_TGA_0.B.n149 ELAD1_TGA_0.B.n112 0.154346
R1360 ELAD1_TGA_0.B.n148 ELAD1_TGA_0.B.n147 0.154346
R1361 ELAD1_TGA_0.B.n146 ELAD1_TGA_0.B.n113 0.154346
R1362 ELAD1_TGA_0.B.n131 ELAD1_TGA_0.B.n113 0.154346
R1363 ELAD1_TGA_0.B.n131 ELAD1_TGA_0.B.n128 0.154346
R1364 ELAD1_TGA_0.B.n138 ELAD1_TGA_0.B.n128 0.154346
R1365 ELAD1_TGA_0.B.n139 ELAD1_TGA_0.B.n138 0.154346
R1366 ELAD1_TGA_0.B.n139 ELAD1_TGA_0.B.n127 0.154346
R1367 ELAD1_TGA_0.B.n127 ELAD1_TGA_0.B.n126 0.154346
R1368 ELAD1_TGA_0.B.n125 ELAD1_TGA_0.B.n121 0.154346
R1369 ELAD1_TGA_0.B.n165 ELAD1_TGA_0.B.n164 0.149538
R1370 ELAD1_TGA_0.B.n93 ELAD1_TGA_0.B.n87 0.149538
R1371 ELAD1_TGA_0.B.n52 ELAD1_TGA_0.B.n46 0.149538
R1372 ELAD1_TGA_0.B.n29 ELAD1_TGA_0.B.n7 0.149538
R1373 ELAD1_TGA_0.B.n124 ELAD1_TGA_0.B.n123 0.149538
R1374 ELAD1_TGA_0.B.n171 ELAD1_TGA_0.B.n170 0.139923
R1375 ELAD1_TGA_0.B.n88 ELAD1_TGA_0.B.n85 0.139923
R1376 ELAD1_TGA_0.B.n47 ELAD1_TGA_0.B.n44 0.139923
R1377 ELAD1_TGA_0.B.n25 ELAD1_TGA_0.B.n23 0.139923
R1378 ELAD1_TGA_0.B.n141 ELAD1_TGA_0.B.n140 0.139923
R1379 ELAD1_TGA_0.B.n189 ELAD1_TGA_0.B.n188 0.126232
R1380 ELAD1_TGA_0.B.n160 ELAD1_TGA_0.B.n159 0.120692
R1381 ELAD1_TGA_0.B.n101 ELAD1_TGA_0.B.n99 0.120692
R1382 ELAD1_TGA_0.B.n60 ELAD1_TGA_0.B.n58 0.120692
R1383 ELAD1_TGA_0.B.n20 ELAD1_TGA_0.B.n9 0.120692
R1384 ELAD1_TGA_0.B.n137 ELAD1_TGA_0.B.n122 0.120692
R1385 ELAD1_TGA_0.B.n186 ELAD1_TGA_0.B.n153 0.118147
R1386 ELAD1_TGA_0.B.n180 ELAD1_TGA_0.B.n153 0.118147
R1387 ELAD1_TGA_0.B.n180 ELAD1_TGA_0.B.n179 0.118147
R1388 ELAD1_TGA_0.B.n179 ELAD1_TGA_0.B.n158 0.118147
R1389 ELAD1_TGA_0.B.n169 ELAD1_TGA_0.B.n158 0.118147
R1390 ELAD1_TGA_0.B.n169 ELAD1_TGA_0.B.n168 0.118147
R1391 ELAD1_TGA_0.B.n168 ELAD1_TGA_0.B.n167 0.118147
R1392 ELAD1_TGA_0.B.n185 ELAD1_TGA_0.B.n154 0.111077
R1393 ELAD1_TGA_0.B.n110 ELAD1_TGA_0.B.n78 0.111077
R1394 ELAD1_TGA_0.B.n69 ELAD1_TGA_0.B.n37 0.111077
R1395 ELAD1_TGA_0.B.n33 ELAD1_TGA_0.B.n2 0.111077
R1396 ELAD1_TGA_0.B.n145 ELAD1_TGA_0.B.n114 0.111077
R1397 ELAD1_TGA_0.B.n178 ELAD1_TGA_0.B.n177 0.101462
R1398 ELAD1_TGA_0.B.n100 ELAD1_TGA_0.B.n82 0.101462
R1399 ELAD1_TGA_0.B.n59 ELAD1_TGA_0.B.n41 0.101462
R1400 ELAD1_TGA_0.B.n19 ELAD1_TGA_0.B.n16 0.101462
R1401 ELAD1_TGA_0.B.n136 ELAD1_TGA_0.B.n129 0.101462
R1402 ELAD1_TGA_0.B.n182 ELAD1_TGA_0.B.n181 0.0918462
R1403 ELAD1_TGA_0.B.n105 ELAD1_TGA_0.B.n83 0.0918462
R1404 ELAD1_TGA_0.B.n64 ELAD1_TGA_0.B.n42 0.0918462
R1405 ELAD1_TGA_0.B.n13 ELAD1_TGA_0.B.n11 0.0918462
R1406 ELAD1_TGA_0.B.n132 ELAD1_TGA_0.B.n130 0.0918462
R1407 ELAD1_TGA_0.B.n181 ELAD1_TGA_0.B.n157 0.0822308
R1408 ELAD1_TGA_0.B.n106 ELAD1_TGA_0.B.n105 0.0822308
R1409 ELAD1_TGA_0.B.n65 ELAD1_TGA_0.B.n64 0.0822308
R1410 ELAD1_TGA_0.B.n15 ELAD1_TGA_0.B.n13 0.0822308
R1411 ELAD1_TGA_0.B.n133 ELAD1_TGA_0.B.n132 0.0822308
R1412 ELAD1_TGA_0.B.n190 ELAD1_TGA_0.B.n189 0.0750192
R1413 ELAD1_TGA_0.B.n178 ELAD1_TGA_0.B.n157 0.0726154
R1414 ELAD1_TGA_0.B.n106 ELAD1_TGA_0.B.n82 0.0726154
R1415 ELAD1_TGA_0.B.n65 ELAD1_TGA_0.B.n41 0.0726154
R1416 ELAD1_TGA_0.B.n16 ELAD1_TGA_0.B.n15 0.0726154
R1417 ELAD1_TGA_0.B.n133 ELAD1_TGA_0.B.n129 0.0726154
R1418 ELAD1_TGA_0.B.n182 ELAD1_TGA_0.B.n154 0.063
R1419 ELAD1_TGA_0.B.n83 ELAD1_TGA_0.B.n78 0.063
R1420 ELAD1_TGA_0.B.n42 ELAD1_TGA_0.B.n37 0.063
R1421 ELAD1_TGA_0.B.n11 ELAD1_TGA_0.B.n2 0.063
R1422 ELAD1_TGA_0.B.n130 ELAD1_TGA_0.B.n114 0.063
R1423 ELAD1_TGA_0.B.n177 ELAD1_TGA_0.B.n159 0.0533846
R1424 ELAD1_TGA_0.B.n101 ELAD1_TGA_0.B.n100 0.0533846
R1425 ELAD1_TGA_0.B.n60 ELAD1_TGA_0.B.n59 0.0533846
R1426 ELAD1_TGA_0.B.n20 ELAD1_TGA_0.B.n19 0.0533846
R1427 ELAD1_TGA_0.B.n137 ELAD1_TGA_0.B.n136 0.0533846
R1428 ELAD1_TGA_0.B.n170 ELAD1_TGA_0.B.n160 0.0341538
R1429 ELAD1_TGA_0.B.n99 ELAD1_TGA_0.B.n85 0.0341538
R1430 ELAD1_TGA_0.B.n58 ELAD1_TGA_0.B.n44 0.0341538
R1431 ELAD1_TGA_0.B.n23 ELAD1_TGA_0.B.n9 0.0341538
R1432 ELAD1_TGA_0.B.n140 ELAD1_TGA_0.B.n122 0.0341538
R1433 ELAD1_TGA_0.B.n171 ELAD1_TGA_0.B.n162 0.0149231
R1434 ELAD1_TGA_0.B.n89 ELAD1_TGA_0.B.n88 0.0149231
R1435 ELAD1_TGA_0.B.n48 ELAD1_TGA_0.B.n47 0.0149231
R1436 ELAD1_TGA_0.B.n26 ELAD1_TGA_0.B.n25 0.0149231
R1437 ELAD1_TGA_0.B.n141 ELAD1_TGA_0.B.n121 0.0149231
R1438 ELAD1_TGA_0.B.n166 ELAD1_TGA_0.B.n165 0.00530769
R1439 ELAD1_TGA_0.B.n93 ELAD1_TGA_0.B.n92 0.00530769
R1440 ELAD1_TGA_0.B.n52 ELAD1_TGA_0.B.n51 0.00530769
R1441 ELAD1_TGA_0.B.n27 ELAD1_TGA_0.B.n7 0.00530769
R1442 ELAD1_TGA_0.B.n125 ELAD1_TGA_0.B.n124 0.00530769
C15 EN VGND 1.8958f
C16 B VGND 1.2737f
C17 A VGND 0.84026f
C18 ENB VGND 0.76651f
C19 VDPWR VGND 9.38588f
C20 ELAD1_TGA_0.B VGND 1.84383f **FLOATING
C21 ELAD1_TGA_0.B.n0 VGND 0.06762f **FLOATING
C22 ELAD1_TGA_0.B.t16 VGND 0.06536f **FLOATING
C23 ELAD1_TGA_0.B.n1 VGND 0.02159f **FLOATING
C24 ELAD1_TGA_0.B.n2 VGND 0.01214f **FLOATING
C25 ELAD1_TGA_0.B.n3 VGND 0.01588f **FLOATING
C26 ELAD1_TGA_0.B.t14 VGND 0.0973f **FLOATING
C27 ELAD1_TGA_0.B.n6 VGND 0.01588f **FLOATING
C28 ELAD1_TGA_0.B.n7 VGND 0.01079f **FLOATING
C29 ELAD1_TGA_0.B.n8 VGND 0.02159f **FLOATING
C30 ELAD1_TGA_0.B.n9 VGND 0.01079f **FLOATING
C31 ELAD1_TGA_0.B.n10 VGND 0.02159f **FLOATING
C32 ELAD1_TGA_0.B.n11 VGND 0.01079f **FLOATING
C33 ELAD1_TGA_0.B.n12 VGND 0.02159f **FLOATING
C34 ELAD1_TGA_0.B.n13 VGND 0.01214f **FLOATING
C35 ELAD1_TGA_0.B.n14 VGND 0.01588f **FLOATING
C36 ELAD1_TGA_0.B.n15 VGND 0.01079f **FLOATING
C37 ELAD1_TGA_0.B.n16 VGND 0.01214f **FLOATING
C38 ELAD1_TGA_0.B.n17 VGND 0.01588f **FLOATING
C39 ELAD1_TGA_0.B.n18 VGND 0.01588f **FLOATING
C40 ELAD1_TGA_0.B.n19 VGND 0.01079f **FLOATING
C41 ELAD1_TGA_0.B.n20 VGND 0.01214f **FLOATING
C42 ELAD1_TGA_0.B.n21 VGND 0.02159f **FLOATING
C43 ELAD1_TGA_0.B.n22 VGND 0.02159f **FLOATING
C44 ELAD1_TGA_0.B.n23 VGND 0.01214f **FLOATING
C45 ELAD1_TGA_0.B.n24 VGND 0.01588f **FLOATING
C46 ELAD1_TGA_0.B.n25 VGND 0.01079f **FLOATING
C47 ELAD1_TGA_0.B.n26 VGND 0.01181f **FLOATING
C48 ELAD1_TGA_0.B.n27 VGND 0.01113f **FLOATING
C49 ELAD1_TGA_0.B.n28 VGND 0.04638f **FLOATING
C50 ELAD1_TGA_0.B.n29 VGND 0.03506f **FLOATING
C51 ELAD1_TGA_0.B.n30 VGND 0.0063f **FLOATING
C52 ELAD1_TGA_0.B.t13 VGND 0.0973f **FLOATING
C53 ELAD1_TGA_0.B.n31 VGND 0.1946f **FLOATING
C54 ELAD1_TGA_0.B.n32 VGND 0.00628f **FLOATING
C55 ELAD1_TGA_0.B.n33 VGND 0.03744f **FLOATING
C56 ELAD1_TGA_0.B.n34 VGND 0.14145f **FLOATING
C57 ELAD1_TGA_0.B.n35 VGND 0.23244f **FLOATING
C58 ELAD1_TGA_0.B.n36 VGND 0.02159f **FLOATING
C59 ELAD1_TGA_0.B.n37 VGND 0.01214f **FLOATING
C60 ELAD1_TGA_0.B.n38 VGND 0.01588f **FLOATING
C61 ELAD1_TGA_0.B.n39 VGND 0.02102f **FLOATING
C62 ELAD1_TGA_0.B.n40 VGND 0.01588f **FLOATING
C63 ELAD1_TGA_0.B.n41 VGND 0.01214f **FLOATING
C64 ELAD1_TGA_0.B.n42 VGND 0.01079f **FLOATING
C65 ELAD1_TGA_0.B.n43 VGND 0.02159f **FLOATING
C66 ELAD1_TGA_0.B.n44 VGND 0.01214f **FLOATING
C67 ELAD1_TGA_0.B.n45 VGND 0.01588f **FLOATING
C68 ELAD1_TGA_0.B.n46 VGND 0.04152f **FLOATING
C69 ELAD1_TGA_0.B.n47 VGND 0.01079f **FLOATING
C70 ELAD1_TGA_0.B.n48 VGND 0.01181f **FLOATING
C71 ELAD1_TGA_0.B.n49 VGND 0.02159f **FLOATING
C72 ELAD1_TGA_0.B.n50 VGND 0.04638f **FLOATING
C73 ELAD1_TGA_0.B.n51 VGND 0.01113f **FLOATING
C74 ELAD1_TGA_0.B.n52 VGND 0.01079f **FLOATING
C75 ELAD1_TGA_0.B.n53 VGND 0.01588f **FLOATING
C76 ELAD1_TGA_0.B.n54 VGND 0.03047f **FLOATING
C77 ELAD1_TGA_0.B.n55 VGND 0.05811f **FLOATING
C78 ELAD1_TGA_0.B.t15 VGND 0.01401f **FLOATING
C79 ELAD1_TGA_0.B.n56 VGND 0.02102f **FLOATING
C80 ELAD1_TGA_0.B.n57 VGND 0.01588f **FLOATING
C81 ELAD1_TGA_0.B.n58 VGND 0.01079f **FLOATING
C82 ELAD1_TGA_0.B.n59 VGND 0.01079f **FLOATING
C83 ELAD1_TGA_0.B.n60 VGND 0.01214f **FLOATING
C84 ELAD1_TGA_0.B.n61 VGND 0.02159f **FLOATING
C85 ELAD1_TGA_0.B.n62 VGND 0.02159f **FLOATING
C86 ELAD1_TGA_0.B.n63 VGND 0.02159f **FLOATING
C87 ELAD1_TGA_0.B.n64 VGND 0.01214f **FLOATING
C88 ELAD1_TGA_0.B.n65 VGND 0.01079f **FLOATING
C89 ELAD1_TGA_0.B.n66 VGND 0.01588f **FLOATING
C90 ELAD1_TGA_0.B.n67 VGND 0.05811f **FLOATING
C91 ELAD1_TGA_0.B.n68 VGND 0.03044f **FLOATING
C92 ELAD1_TGA_0.B.n69 VGND 0.04391f **FLOATING
C93 ELAD1_TGA_0.B.n70 VGND 0.07523f **FLOATING
C94 ELAD1_TGA_0.B.n71 VGND 0.24618f **FLOATING
C95 ELAD1_TGA_0.B.t7 VGND 0.03243f **FLOATING
C96 ELAD1_TGA_0.B.t6 VGND 0.03243f **FLOATING
C97 ELAD1_TGA_0.B.n72 VGND 0.07478f **FLOATING
C98 ELAD1_TGA_0.B.n73 VGND 0.43132f **FLOATING
C99 ELAD1_TGA_0.B.t5 VGND 0.03243f **FLOATING
C100 ELAD1_TGA_0.B.t4 VGND 0.03243f **FLOATING
C101 ELAD1_TGA_0.B.n74 VGND 0.07478f **FLOATING
C102 ELAD1_TGA_0.B.n75 VGND 0.41169f **FLOATING
C103 ELAD1_TGA_0.B.n76 VGND 0.39362f **FLOATING
C104 ELAD1_TGA_0.B.n77 VGND 0.02159f **FLOATING
C105 ELAD1_TGA_0.B.n78 VGND 0.01214f **FLOATING
C106 ELAD1_TGA_0.B.n79 VGND 0.01588f **FLOATING
C107 ELAD1_TGA_0.B.n80 VGND 0.02102f **FLOATING
C108 ELAD1_TGA_0.B.n81 VGND 0.01588f **FLOATING
C109 ELAD1_TGA_0.B.n82 VGND 0.01214f **FLOATING
C110 ELAD1_TGA_0.B.n83 VGND 0.01079f **FLOATING
C111 ELAD1_TGA_0.B.n84 VGND 0.02159f **FLOATING
C112 ELAD1_TGA_0.B.n85 VGND 0.01214f **FLOATING
C113 ELAD1_TGA_0.B.n86 VGND 0.01588f **FLOATING
C114 ELAD1_TGA_0.B.n87 VGND 0.04152f **FLOATING
C115 ELAD1_TGA_0.B.n88 VGND 0.01079f **FLOATING
C116 ELAD1_TGA_0.B.n89 VGND 0.01181f **FLOATING
C117 ELAD1_TGA_0.B.n90 VGND 0.02159f **FLOATING
C118 ELAD1_TGA_0.B.n91 VGND 0.04638f **FLOATING
C119 ELAD1_TGA_0.B.n92 VGND 0.01113f **FLOATING
C120 ELAD1_TGA_0.B.n93 VGND 0.01079f **FLOATING
C121 ELAD1_TGA_0.B.n94 VGND 0.01588f **FLOATING
C122 ELAD1_TGA_0.B.n95 VGND 0.03047f **FLOATING
C123 ELAD1_TGA_0.B.n96 VGND 0.05811f **FLOATING
C124 ELAD1_TGA_0.B.t12 VGND 0.01401f **FLOATING
C125 ELAD1_TGA_0.B.n97 VGND 0.02102f **FLOATING
C126 ELAD1_TGA_0.B.n98 VGND 0.01588f **FLOATING
C127 ELAD1_TGA_0.B.n99 VGND 0.01079f **FLOATING
C128 ELAD1_TGA_0.B.n100 VGND 0.01079f **FLOATING
C129 ELAD1_TGA_0.B.n101 VGND 0.01214f **FLOATING
C130 ELAD1_TGA_0.B.n102 VGND 0.02159f **FLOATING
C131 ELAD1_TGA_0.B.n103 VGND 0.02159f **FLOATING
C132 ELAD1_TGA_0.B.n104 VGND 0.02159f **FLOATING
C133 ELAD1_TGA_0.B.n105 VGND 0.01214f **FLOATING
C134 ELAD1_TGA_0.B.n106 VGND 0.01079f **FLOATING
C135 ELAD1_TGA_0.B.n107 VGND 0.01588f **FLOATING
C136 ELAD1_TGA_0.B.n108 VGND 0.05811f **FLOATING
C137 ELAD1_TGA_0.B.n109 VGND 0.03044f **FLOATING
C138 ELAD1_TGA_0.B.n110 VGND 0.04391f **FLOATING
C139 ELAD1_TGA_0.B.n111 VGND 0.05783f **FLOATING
C140 ELAD1_TGA_0.B.t3 VGND 0.06556f **FLOATING
C141 ELAD1_TGA_0.B.n112 VGND 0.05852f **FLOATING
C142 ELAD1_TGA_0.B.n113 VGND 0.02159f **FLOATING
C143 ELAD1_TGA_0.B.n114 VGND 0.01214f **FLOATING
C144 ELAD1_TGA_0.B.n115 VGND 0.01588f **FLOATING
C145 ELAD1_TGA_0.B.t9 VGND 0.0973f **FLOATING
C146 ELAD1_TGA_0.B.n116 VGND 0.0063f **FLOATING
C147 ELAD1_TGA_0.B.n119 VGND 0.01588f **FLOATING
C148 ELAD1_TGA_0.B.n120 VGND 0.01588f **FLOATING
C149 ELAD1_TGA_0.B.n121 VGND 0.01181f **FLOATING
C150 ELAD1_TGA_0.B.n122 VGND 0.01079f **FLOATING
C151 ELAD1_TGA_0.B.n123 VGND 0.03506f **FLOATING
C152 ELAD1_TGA_0.B.n124 VGND 0.01079f **FLOATING
C153 ELAD1_TGA_0.B.n125 VGND 0.01113f **FLOATING
C154 ELAD1_TGA_0.B.n126 VGND 0.04638f **FLOATING
C155 ELAD1_TGA_0.B.n127 VGND 0.02159f **FLOATING
C156 ELAD1_TGA_0.B.n128 VGND 0.02159f **FLOATING
C157 ELAD1_TGA_0.B.n129 VGND 0.01214f **FLOATING
C158 ELAD1_TGA_0.B.n130 VGND 0.01079f **FLOATING
C159 ELAD1_TGA_0.B.n131 VGND 0.02159f **FLOATING
C160 ELAD1_TGA_0.B.n132 VGND 0.01214f **FLOATING
C161 ELAD1_TGA_0.B.n133 VGND 0.01079f **FLOATING
C162 ELAD1_TGA_0.B.n134 VGND 0.01588f **FLOATING
C163 ELAD1_TGA_0.B.n135 VGND 0.01588f **FLOATING
C164 ELAD1_TGA_0.B.n136 VGND 0.01079f **FLOATING
C165 ELAD1_TGA_0.B.n137 VGND 0.01214f **FLOATING
C166 ELAD1_TGA_0.B.n138 VGND 0.02159f **FLOATING
C167 ELAD1_TGA_0.B.n139 VGND 0.02159f **FLOATING
C168 ELAD1_TGA_0.B.n140 VGND 0.01214f **FLOATING
C169 ELAD1_TGA_0.B.n141 VGND 0.01079f **FLOATING
C170 ELAD1_TGA_0.B.n142 VGND 0.01588f **FLOATING
C171 ELAD1_TGA_0.B.t8 VGND 0.0973f **FLOATING
C172 ELAD1_TGA_0.B.n143 VGND 0.1946f **FLOATING
C173 ELAD1_TGA_0.B.n144 VGND 0.01522f **FLOATING
C174 ELAD1_TGA_0.B.n145 VGND 0.0285f **FLOATING
C175 ELAD1_TGA_0.B.n146 VGND 0.09284f **FLOATING
C176 ELAD1_TGA_0.B.t0 VGND 0.06533f **FLOATING
C177 ELAD1_TGA_0.B.n147 VGND 0.30315f **FLOATING
C178 ELAD1_TGA_0.B.n148 VGND 0.10159f **FLOATING
C179 ELAD1_TGA_0.B.n149 VGND 0.04082f **FLOATING
C180 ELAD1_TGA_0.B.t2 VGND 0.03243f **FLOATING
C181 ELAD1_TGA_0.B.t1 VGND 0.03243f **FLOATING
C182 ELAD1_TGA_0.B.n150 VGND 0.07737f **FLOATING
C183 ELAD1_TGA_0.B.n151 VGND 0.48021f **FLOATING
C184 ELAD1_TGA_0.B.n152 VGND 0.3702f **FLOATING
C185 ELAD1_TGA_0.B.n153 VGND 0.02823f **FLOATING
C186 ELAD1_TGA_0.B.n154 VGND 0.01214f **FLOATING
C187 ELAD1_TGA_0.B.t11 VGND 0.0973f **FLOATING
C188 ELAD1_TGA_0.B.t10 VGND 0.0973f **FLOATING
C189 ELAD1_TGA_0.B.n155 VGND 0.1946f **FLOATING
C190 ELAD1_TGA_0.B.n156 VGND 0.01588f **FLOATING
C191 ELAD1_TGA_0.B.n157 VGND 0.01079f **FLOATING
C192 ELAD1_TGA_0.B.n158 VGND 0.02823f **FLOATING
C193 ELAD1_TGA_0.B.n159 VGND 0.01214f **FLOATING
C194 ELAD1_TGA_0.B.n160 VGND 0.01079f **FLOATING
C195 ELAD1_TGA_0.B.n161 VGND 0.01588f **FLOATING
C196 ELAD1_TGA_0.B.n162 VGND 0.01181f **FLOATING
C197 ELAD1_TGA_0.B.n163 VGND 0.0063f **FLOATING
C198 ELAD1_TGA_0.B.n164 VGND 0.03506f **FLOATING
C199 ELAD1_TGA_0.B.n165 VGND 0.01079f **FLOATING
C200 ELAD1_TGA_0.B.n166 VGND 0.01113f **FLOATING
C201 ELAD1_TGA_0.B.n167 VGND 0.06039f **FLOATING
C202 ELAD1_TGA_0.B.n168 VGND 0.02823f **FLOATING
C203 ELAD1_TGA_0.B.n169 VGND 0.02823f **FLOATING
C204 ELAD1_TGA_0.B.n170 VGND 0.01214f **FLOATING
C205 ELAD1_TGA_0.B.n171 VGND 0.01079f **FLOATING
C206 ELAD1_TGA_0.B.n172 VGND 0.01588f **FLOATING
C207 ELAD1_TGA_0.B.n174 VGND 0.01588f **FLOATING
C208 ELAD1_TGA_0.B.n176 VGND 0.01588f **FLOATING
C209 ELAD1_TGA_0.B.n177 VGND 0.01079f **FLOATING
C210 ELAD1_TGA_0.B.n178 VGND 0.01214f **FLOATING
C211 ELAD1_TGA_0.B.n179 VGND 0.02823f **FLOATING
C212 ELAD1_TGA_0.B.n180 VGND 0.02823f **FLOATING
C213 ELAD1_TGA_0.B.n181 VGND 0.01214f **FLOATING
C214 ELAD1_TGA_0.B.n182 VGND 0.01079f **FLOATING
C215 ELAD1_TGA_0.B.n183 VGND 0.01588f **FLOATING
C216 ELAD1_TGA_0.B.n184 VGND 0.00628f **FLOATING
C217 ELAD1_TGA_0.B.n185 VGND 0.03744f **FLOATING
C218 ELAD1_TGA_0.B.n186 VGND 0.06675f **FLOATING
C219 ELAD1_TGA_0.B.n187 VGND 0.26966f **FLOATING
C220 ELAD1_TGA_0.B.n188 VGND 0.2463f **FLOATING
C221 ELAD1_TGA_0.B.n189 VGND 0.01861f **FLOATING
C222 ELAD1_TGA_0.B.n190 VGND 0.07267f **FLOATING
C223 ELAD1_TGA_0.B.n191 VGND 0.03152f **FLOATING
C224 VDPWR.n0 VGND 0.01763f **FLOATING
C225 VDPWR.n1 VGND 0.00406f **FLOATING
C226 VDPWR.n2 VGND 0.003f **FLOATING
C227 VDPWR.n3 VGND 0.00603f **FLOATING
C228 VDPWR.n4 VGND 0.003f **FLOATING
C229 VDPWR.n5 VGND 0.10758f **FLOATING
C230 VDPWR.n9 VGND 0.006f **FLOATING
C231 VDPWR.n10 VGND 0.003f **FLOATING
C232 VDPWR.n11 VGND 0.003f **FLOATING
C233 VDPWR.n12 VGND 0.003f **FLOATING
C234 VDPWR.n13 VGND 0.003f **FLOATING
C235 VDPWR.n14 VGND 0.003f **FLOATING
C236 VDPWR.n15 VGND 0.003f **FLOATING
C237 VDPWR.n16 VGND 0.003f **FLOATING
C238 VDPWR.t0 VGND 0.04611f **FLOATING
C239 VDPWR.n17 VGND 0.003f **FLOATING
C240 VDPWR.n18 VGND 0.00406f **FLOATING
C241 VDPWR.n19 VGND 0.01763f **FLOATING
C242 VDPWR.n20 VGND 0.00406f **FLOATING
C243 VDPWR.n21 VGND 0.003f **FLOATING
C244 VDPWR.t1 VGND 0.04611f **FLOATING
C245 VDPWR.n22 VGND 0.003f **FLOATING
C246 VDPWR.n23 VGND 0.003f **FLOATING
C247 VDPWR.n24 VGND 0.003f **FLOATING
C248 VDPWR.n25 VGND 0.05443f **FLOATING
C249 VDPWR.n26 VGND 0.05443f **FLOATING
C250 VDPWR.n27 VGND 0.003f **FLOATING
C251 VDPWR.n28 VGND 0.00406f **FLOATING
C252 VDPWR.n29 VGND 0.01763f **FLOATING
C253 VDPWR.n30 VGND 0.00406f **FLOATING
C254 VDPWR.n31 VGND 0.003f **FLOATING
C255 VDPWR.n32 VGND 0.07108f **FLOATING
C256 VDPWR.n33 VGND 0.003f **FLOATING
C257 VDPWR.n34 VGND 0.00603f **FLOATING
C258 VDPWR.n35 VGND 0.00603f **FLOATING
C259 VDPWR.n36 VGND 0.10758f **FLOATING
C260 VDPWR.t3 VGND 0.04611f **FLOATING
C261 VDPWR.n37 VGND 0.00603f **FLOATING
C262 VDPWR.n38 VGND 0.00406f **FLOATING
C263 VDPWR.n39 VGND 0.06097f **FLOATING
C264 VDPWR.n40 VGND 0.003f **FLOATING
C265 VDPWR.n41 VGND 0.10758f **FLOATING
C266 VDPWR.n42 VGND 0.003f **FLOATING
C267 VDPWR.n47 VGND 0.00603f **FLOATING
C268 VDPWR.n48 VGND 0.003f **FLOATING
C269 VDPWR.n49 VGND 0.00595f **FLOATING
C270 VDPWR.n50 VGND 0.00603f **FLOATING
C271 VDPWR.n51 VGND 0.003f **FLOATING
C272 VDPWR.n52 VGND 0.003f **FLOATING
C273 VDPWR.t4 VGND 0.04611f **FLOATING
C274 VDPWR.n53 VGND 0.003f **FLOATING
C275 VDPWR.n54 VGND 0.00406f **FLOATING
C276 VDPWR.n55 VGND 0.00406f **FLOATING
C277 VDPWR.n56 VGND 0.01763f **FLOATING
C278 VDPWR.n57 VGND 0.00406f **FLOATING
C279 VDPWR.n58 VGND 0.003f **FLOATING
C280 VDPWR.t5 VGND 0.04611f **FLOATING
C281 VDPWR.n59 VGND 0.003f **FLOATING
C282 VDPWR.n60 VGND 0.003f **FLOATING
C283 VDPWR.n61 VGND 0.003f **FLOATING
C284 VDPWR.n62 VGND 0.05443f **FLOATING
C285 VDPWR.n63 VGND 0.05443f **FLOATING
C286 VDPWR.n64 VGND 0.003f **FLOATING
C287 VDPWR.n65 VGND 0.00406f **FLOATING
C288 VDPWR.n66 VGND 0.01763f **FLOATING
C289 VDPWR.n67 VGND 0.00406f **FLOATING
C290 VDPWR.n68 VGND 0.003f **FLOATING
C291 VDPWR.n69 VGND 0.07108f **FLOATING
C292 VDPWR.n70 VGND 0.003f **FLOATING
C293 VDPWR.n71 VGND 0.00603f **FLOATING
C294 VDPWR.n72 VGND 0.00603f **FLOATING
C295 VDPWR.n73 VGND 0.10758f **FLOATING
C296 VDPWR.t7 VGND 0.04611f **FLOATING
C297 VDPWR.n74 VGND 0.00603f **FLOATING
C298 VDPWR.n75 VGND 0.00406f **FLOATING
C299 VDPWR.n76 VGND 0.003f **FLOATING
C300 VDPWR.n77 VGND 0.30353f **FLOATING
C301 VDPWR.n78 VGND 0.003f **FLOATING
C302 VDPWR.n79 VGND 0.003f **FLOATING
C303 VDPWR.n80 VGND 0.003f **FLOATING
C304 VDPWR.n82 VGND 0.003f **FLOATING
C305 VDPWR.n84 VGND 0.006f **FLOATING
C306 VDPWR.n85 VGND 0.006f **FLOATING
C307 VDPWR.n86 VGND 0.003f **FLOATING
C308 VDPWR.n87 VGND 0.003f **FLOATING
C309 VDPWR.n88 VGND 0.003f **FLOATING
C310 VDPWR.n90 VGND 0.003f **FLOATING
C311 VDPWR.n91 VGND 0.003f **FLOATING
C312 VDPWR.n92 VGND 0.003f **FLOATING
C313 VDPWR.n93 VGND 0.003f **FLOATING
C314 VDPWR.n94 VGND 0.003f **FLOATING
C315 VDPWR.n95 VGND 0.003f **FLOATING
C316 VDPWR.n97 VGND 0.003f **FLOATING
C317 VDPWR.n98 VGND 0.003f **FLOATING
C318 VDPWR.n100 VGND 0.006f **FLOATING
C319 VDPWR.n101 VGND 0.00481f **FLOATING
C320 VDPWR.n102 VGND 0.00718f **FLOATING
C321 VDPWR.n103 VGND 0.09441f **FLOATING
C322 VDPWR.n104 VGND 0.00406f **FLOATING
C323 VDPWR.n105 VGND 0.003f **FLOATING
C324 VDPWR.n106 VGND 0.06724f **FLOATING
C325 VDPWR.n107 VGND 0.003f **FLOATING
C326 VDPWR.n108 VGND 0.003f **FLOATING
C327 VDPWR.n109 VGND 0.003f **FLOATING
C328 VDPWR.n110 VGND 0.003f **FLOATING
C329 VDPWR.n111 VGND 0.003f **FLOATING
C330 VDPWR.t6 VGND 0.04611f **FLOATING
C331 VDPWR.n112 VGND 0.08389f **FLOATING
C332 VDPWR.n113 VGND 0.003f **FLOATING
C333 VDPWR.n114 VGND 0.00406f **FLOATING
C334 VDPWR.n115 VGND 0.01763f **FLOATING
C335 VDPWR.n116 VGND 0.01763f **FLOATING
C336 VDPWR.n117 VGND 0.01763f **FLOATING
C337 VDPWR.n118 VGND 0.00406f **FLOATING
C338 VDPWR.n119 VGND 0.003f **FLOATING
C339 VDPWR.n120 VGND 0.09221f **FLOATING
C340 VDPWR.n121 VGND 0.003f **FLOATING
C341 VDPWR.n122 VGND 0.003f **FLOATING
C342 VDPWR.n123 VGND 0.003f **FLOATING
C343 VDPWR.n124 VGND 0.003f **FLOATING
C344 VDPWR.n125 VGND 0.003f **FLOATING
C345 VDPWR.n126 VGND 0.003f **FLOATING
C346 VDPWR.n127 VGND 0.07108f **FLOATING
C347 VDPWR.n128 VGND 0.08389f **FLOATING
C348 VDPWR.n129 VGND 0.003f **FLOATING
C349 VDPWR.n130 VGND 0.00406f **FLOATING
C350 VDPWR.n131 VGND 0.01763f **FLOATING
C351 VDPWR.n132 VGND 0.01763f **FLOATING
C352 VDPWR.n133 VGND 0.01763f **FLOATING
C353 VDPWR.n134 VGND 0.01763f **FLOATING
C354 VDPWR.n135 VGND 0.00406f **FLOATING
C355 VDPWR.n136 VGND 0.003f **FLOATING
C356 VDPWR.n137 VGND 0.06724f **FLOATING
C357 VDPWR.n138 VGND 0.003f **FLOATING
C358 VDPWR.n139 VGND 0.00603f **FLOATING
C359 VDPWR.n140 VGND 0.006f **FLOATING
C360 VDPWR.n141 VGND 0.006f **FLOATING
C361 VDPWR.n142 VGND 0.003f **FLOATING
C362 VDPWR.n143 VGND 0.003f **FLOATING
C363 VDPWR.n144 VGND 0.003f **FLOATING
C364 VDPWR.n145 VGND 0.003f **FLOATING
C365 VDPWR.n146 VGND 0.003f **FLOATING
C366 VDPWR.n147 VGND 0.003f **FLOATING
C367 VDPWR.n148 VGND 0.003f **FLOATING
C368 VDPWR.n149 VGND 0.003f **FLOATING
C369 VDPWR.n150 VGND 0.003f **FLOATING
C370 VDPWR.n151 VGND 0.003f **FLOATING
C371 VDPWR.n152 VGND 0.003f **FLOATING
C372 VDPWR.n153 VGND 0.003f **FLOATING
C373 VDPWR.n154 VGND 0.003f **FLOATING
C374 VDPWR.n155 VGND 0.003f **FLOATING
C375 VDPWR.n156 VGND 0.00422f **FLOATING
C376 VDPWR.n157 VGND 0.006f **FLOATING
C377 VDPWR.n158 VGND 0.30353f **FLOATING
C378 VDPWR.n159 VGND 0.30353f **FLOATING
C379 VDPWR.n160 VGND 0.003f **FLOATING
C380 VDPWR.n161 VGND 0.003f **FLOATING
C381 VDPWR.n162 VGND 0.003f **FLOATING
C382 VDPWR.n164 VGND 0.003f **FLOATING
C383 VDPWR.n166 VGND 0.006f **FLOATING
C384 VDPWR.n167 VGND 0.006f **FLOATING
C385 VDPWR.n168 VGND 0.003f **FLOATING
C386 VDPWR.n169 VGND 0.003f **FLOATING
C387 VDPWR.n170 VGND 0.003f **FLOATING
C388 VDPWR.n172 VGND 0.003f **FLOATING
C389 VDPWR.n173 VGND 0.003f **FLOATING
C390 VDPWR.n174 VGND 0.003f **FLOATING
C391 VDPWR.n175 VGND 0.003f **FLOATING
C392 VDPWR.n176 VGND 0.003f **FLOATING
C393 VDPWR.n177 VGND 0.003f **FLOATING
C394 VDPWR.n179 VGND 0.003f **FLOATING
C395 VDPWR.n180 VGND 0.003f **FLOATING
C396 VDPWR.n182 VGND 0.006f **FLOATING
C397 VDPWR.n183 VGND 0.00422f **FLOATING
C398 VDPWR.n184 VGND 0.00595f **FLOATING
C399 VDPWR.n185 VGND 0.06097f **FLOATING
C400 VDPWR.n186 VGND 0.01763f **FLOATING
C401 VDPWR.n187 VGND 0.01763f **FLOATING
C402 VDPWR.n188 VGND 0.00406f **FLOATING
C403 VDPWR.n189 VGND 0.003f **FLOATING
C404 VDPWR.n190 VGND 0.06724f **FLOATING
C405 VDPWR.n191 VGND 0.003f **FLOATING
C406 VDPWR.n192 VGND 0.003f **FLOATING
C407 VDPWR.n193 VGND 0.003f **FLOATING
C408 VDPWR.n194 VGND 0.003f **FLOATING
C409 VDPWR.n195 VGND 0.003f **FLOATING
C410 VDPWR.t2 VGND 0.04611f **FLOATING
C411 VDPWR.n196 VGND 0.08389f **FLOATING
C412 VDPWR.n197 VGND 0.003f **FLOATING
C413 VDPWR.n198 VGND 0.00406f **FLOATING
C414 VDPWR.n199 VGND 0.01763f **FLOATING
C415 VDPWR.n200 VGND 0.01763f **FLOATING
C416 VDPWR.n201 VGND 0.01763f **FLOATING
C417 VDPWR.n202 VGND 0.00406f **FLOATING
C418 VDPWR.n203 VGND 0.003f **FLOATING
C419 VDPWR.n204 VGND 0.09221f **FLOATING
C420 VDPWR.n205 VGND 0.003f **FLOATING
C421 VDPWR.n206 VGND 0.003f **FLOATING
C422 VDPWR.n207 VGND 0.003f **FLOATING
C423 VDPWR.n208 VGND 0.003f **FLOATING
C424 VDPWR.n209 VGND 0.003f **FLOATING
C425 VDPWR.n210 VGND 0.003f **FLOATING
C426 VDPWR.n211 VGND 0.07108f **FLOATING
C427 VDPWR.n212 VGND 0.08389f **FLOATING
C428 VDPWR.n213 VGND 0.003f **FLOATING
C429 VDPWR.n214 VGND 0.00406f **FLOATING
C430 VDPWR.n215 VGND 0.01763f **FLOATING
C431 VDPWR.n216 VGND 0.01763f **FLOATING
C432 VDPWR.n217 VGND 0.01763f **FLOATING
C433 VDPWR.n218 VGND 0.00406f **FLOATING
C434 VDPWR.n219 VGND 0.003f **FLOATING
C435 VDPWR.n220 VGND 0.06724f **FLOATING
C436 VDPWR.n221 VGND 0.003f **FLOATING
C437 VDPWR.n222 VGND 0.00603f **FLOATING
C438 VDPWR.n223 VGND 0.00603f **FLOATING
C439 VDPWR.n224 VGND 0.006f **FLOATING
C440 VDPWR.n225 VGND 0.003f **FLOATING
C441 VDPWR.n226 VGND 0.003f **FLOATING
C442 VDPWR.n227 VGND 0.003f **FLOATING
C443 VDPWR.n228 VGND 0.003f **FLOATING
C444 VDPWR.n229 VGND 0.003f **FLOATING
C445 VDPWR.n230 VGND 0.003f **FLOATING
C446 VDPWR.n231 VGND 0.003f **FLOATING
C447 VDPWR.n232 VGND 0.003f **FLOATING
C448 VDPWR.n233 VGND 0.003f **FLOATING
C449 VDPWR.n234 VGND 0.30353f **FLOATING
C450 VDPWR.n236 VGND 0.006f **FLOATING
C451 VDPWR.n237 VGND 0.00422f **FLOATING
C452 VDPWR.n238 VGND 0.00595f **FLOATING
C453 VDPWR.n239 VGND 0.03477f **FLOATING
C454 ENB.t1 VGND 0.29502f **FLOATING
C455 ENB.t2 VGND 0.29481f **FLOATING
C456 ENB.n0 VGND 0.32455f **FLOATING
C457 ENB.t3 VGND 0.29481f **FLOATING
C458 ENB.n1 VGND 0.13388f **FLOATING
C459 ENB.t4 VGND 0.29481f **FLOATING
C460 ENB.n2 VGND 0.16853f **FLOATING
C461 ENB.t0 VGND 0.0671f **FLOATING
C462 ENB.n3 VGND 0.59763f **FLOATING
C463 ENB.t5 VGND 0.29481f **FLOATING
C464 ENB.n4 VGND 0.1679f **FLOATING
C465 ENB.t6 VGND 0.29481f **FLOATING
C466 ENB.n5 VGND 0.13388f **FLOATING
C467 ENB.t7 VGND 0.29481f **FLOATING
C468 ENB.n6 VGND 0.13388f **FLOATING
C469 ENB.t8 VGND 0.29481f **FLOATING
C470 ENB.n7 VGND 0.14892f **FLOATING
C471 A.n0 VGND 0.07127f **FLOATING
C472 A.n1 VGND 0.02275f **FLOATING
C473 A.n2 VGND 0.0128f **FLOATING
C474 A.n3 VGND 0.01674f **FLOATING
C475 A.n4 VGND 0.02215f **FLOATING
C476 A.n5 VGND 0.01674f **FLOATING
C477 A.n6 VGND 0.0128f **FLOATING
C478 A.n7 VGND 0.01138f **FLOATING
C479 A.n8 VGND 0.02275f **FLOATING
C480 A.n9 VGND 0.0128f **FLOATING
C481 A.n10 VGND 0.01674f **FLOATING
C482 A.n11 VGND 0.04376f **FLOATING
C483 A.n12 VGND 0.01138f **FLOATING
C484 A.n13 VGND 0.01244f **FLOATING
C485 A.n14 VGND 0.02275f **FLOATING
C486 A.n15 VGND 0.04888f **FLOATING
C487 A.n16 VGND 0.01173f **FLOATING
C488 A.n17 VGND 0.01138f **FLOATING
C489 A.n18 VGND 0.01674f **FLOATING
C490 A.n19 VGND 0.03212f **FLOATING
C491 A.n20 VGND 0.06125f **FLOATING
C492 A.t0 VGND 0.01477f **FLOATING
C493 A.n21 VGND 0.02215f **FLOATING
C494 A.n22 VGND 0.01674f **FLOATING
C495 A.n23 VGND 0.01138f **FLOATING
C496 A.n24 VGND 0.01138f **FLOATING
C497 A.n25 VGND 0.0128f **FLOATING
C498 A.n26 VGND 0.02275f **FLOATING
C499 A.n27 VGND 0.02275f **FLOATING
C500 A.n28 VGND 0.02275f **FLOATING
C501 A.n29 VGND 0.0128f **FLOATING
C502 A.n30 VGND 0.01138f **FLOATING
C503 A.n31 VGND 0.01674f **FLOATING
C504 A.n32 VGND 0.06125f **FLOATING
C505 A.n33 VGND 0.03209f **FLOATING
C506 A.n34 VGND 0.04628f **FLOATING
C507 A.n35 VGND 0.07676f **FLOATING
C508 A.n36 VGND 0.07639f **FLOATING
C509 A.n37 VGND 0.02275f **FLOATING
C510 A.n38 VGND 0.0128f **FLOATING
C511 A.n39 VGND 0.01674f **FLOATING
C512 A.t2 VGND 0.10256f **FLOATING
C513 A.t1 VGND 0.10256f **FLOATING
C514 A.n42 VGND 0.03696f **FLOATING
C515 A.n43 VGND 0.01674f **FLOATING
C516 A.n44 VGND 0.01244f **FLOATING
C517 A.n45 VGND 0.02275f **FLOATING
C518 A.n46 VGND 0.01138f **FLOATING
C519 A.n47 VGND 0.0128f **FLOATING
C520 A.n48 VGND 0.01674f **FLOATING
C521 A.n49 VGND 0.01138f **FLOATING
C522 A.n50 VGND 0.01138f **FLOATING
C523 A.n51 VGND 0.0128f **FLOATING
C524 A.n52 VGND 0.02275f **FLOATING
C525 A.n53 VGND 0.02275f **FLOATING
C526 A.n54 VGND 0.0128f **FLOATING
C527 A.n55 VGND 0.01138f **FLOATING
C528 A.n56 VGND 0.01674f **FLOATING
C529 A.n57 VGND 0.01674f **FLOATING
C530 A.n58 VGND 0.01138f **FLOATING
C531 A.n59 VGND 0.0128f **FLOATING
C532 A.n60 VGND 0.02275f **FLOATING
C533 A.n61 VGND 0.02275f **FLOATING
C534 A.n62 VGND 0.04888f **FLOATING
C535 A.n63 VGND 0.01173f **FLOATING
C536 A.n64 VGND 0.01138f **FLOATING
C537 A.n65 VGND 0.01674f **FLOATING
C538 A.n66 VGND 0.00664f **FLOATING
C539 A.n67 VGND 0.20511f **FLOATING
C540 A.n68 VGND 0.00662f **FLOATING
C541 A.n69 VGND 0.03946f **FLOATING
C542 A.n70 VGND 0.14909f **FLOATING
C543 A.n71 VGND 0.24499f **FLOATING
C544 A.n72 VGND 0.02275f **FLOATING
C545 A.n73 VGND 0.0128f **FLOATING
C546 A.n74 VGND 0.01674f **FLOATING
C547 A.n75 VGND 0.02215f **FLOATING
C548 A.n76 VGND 0.01674f **FLOATING
C549 A.n77 VGND 0.0128f **FLOATING
C550 A.n78 VGND 0.01138f **FLOATING
C551 A.n79 VGND 0.02275f **FLOATING
C552 A.n80 VGND 0.0128f **FLOATING
C553 A.n81 VGND 0.01674f **FLOATING
C554 A.n82 VGND 0.04376f **FLOATING
C555 A.n83 VGND 0.01138f **FLOATING
C556 A.n84 VGND 0.01244f **FLOATING
C557 A.n85 VGND 0.02275f **FLOATING
C558 A.n86 VGND 0.04888f **FLOATING
C559 A.n87 VGND 0.01173f **FLOATING
C560 A.n88 VGND 0.01138f **FLOATING
C561 A.n89 VGND 0.01674f **FLOATING
C562 A.n90 VGND 0.03212f **FLOATING
C563 A.n91 VGND 0.06125f **FLOATING
C564 A.t7 VGND 0.01477f **FLOATING
C565 A.n92 VGND 0.02215f **FLOATING
C566 A.n93 VGND 0.01674f **FLOATING
C567 A.n94 VGND 0.01138f **FLOATING
C568 A.n95 VGND 0.01138f **FLOATING
C569 A.n96 VGND 0.0128f **FLOATING
C570 A.n97 VGND 0.02275f **FLOATING
C571 A.n98 VGND 0.02275f **FLOATING
C572 A.n99 VGND 0.02275f **FLOATING
C573 A.n100 VGND 0.0128f **FLOATING
C574 A.n101 VGND 0.01138f **FLOATING
C575 A.n102 VGND 0.01674f **FLOATING
C576 A.n103 VGND 0.06125f **FLOATING
C577 A.n104 VGND 0.03209f **FLOATING
C578 A.n105 VGND 0.04628f **FLOATING
C579 A.n106 VGND 0.07929f **FLOATING
C580 A.n107 VGND 0.25948f **FLOATING
C581 A.t3 VGND 0.03419f **FLOATING
C582 A.t4 VGND 0.03419f **FLOATING
C583 A.n108 VGND 0.07882f **FLOATING
C584 A.n109 VGND 0.45462f **FLOATING
C585 A.t5 VGND 0.03419f **FLOATING
C586 A.t6 VGND 0.03419f **FLOATING
C587 A.n110 VGND 0.07882f **FLOATING
C588 A.n111 VGND 0.45443f **FLOATING
C589 A.n112 VGND 0.15334f **FLOATING
C590 A.n113 VGND 0.03322f **FLOATING
C591 B.n0 VGND 0.01491f **FLOATING
C592 B.t3 VGND 0.06557f **FLOATING
C593 B.t4 VGND 0.06581f **FLOATING
C594 B.n1 VGND 0.02834f **FLOATING
C595 B.n2 VGND 0.01219f **FLOATING
C596 B.n3 VGND 0.01594f **FLOATING
C597 B.t0 VGND 0.09767f **FLOATING
C598 B.n5 VGND 0.01594f **FLOATING
C599 B.t1 VGND 0.09767f **FLOATING
C600 B.n7 VGND 0.01594f **FLOATING
C601 B.n8 VGND 0.01084f **FLOATING
C602 B.n9 VGND 0.02834f **FLOATING
C603 B.n10 VGND 0.01084f **FLOATING
C604 B.n11 VGND 0.02834f **FLOATING
C605 B.n12 VGND 0.01084f **FLOATING
C606 B.n13 VGND 0.02834f **FLOATING
C607 B.n14 VGND 0.01219f **FLOATING
C608 B.n15 VGND 0.01594f **FLOATING
C609 B.n16 VGND 0.01084f **FLOATING
C610 B.n17 VGND 0.01219f **FLOATING
C611 B.n18 VGND 0.01594f **FLOATING
C612 B.n19 VGND 0.01084f **FLOATING
C613 B.n20 VGND 0.01219f **FLOATING
C614 B.n21 VGND 0.02834f **FLOATING
C615 B.n22 VGND 0.02834f **FLOATING
C616 B.n23 VGND 0.01219f **FLOATING
C617 B.n24 VGND 0.01594f **FLOATING
C618 B.n25 VGND 0.01084f **FLOATING
C619 B.n26 VGND 0.01185f **FLOATING
C620 B.n27 VGND 0.01117f **FLOATING
C621 B.n28 VGND 0.06063f **FLOATING
C622 B.n29 VGND 0.02621f **FLOATING
C623 B.n30 VGND 0.01531f **FLOATING
C624 B.n31 VGND 0.19535f **FLOATING
C625 B.n32 VGND 0.0063f **FLOATING
C626 B.n33 VGND 0.03759f **FLOATING
C627 B.n34 VGND 0.1087f **FLOATING
C628 B.n35 VGND 0.42386f **FLOATING
C629 B.t2 VGND 0.03256f **FLOATING
C630 B.t5 VGND 0.03256f **FLOATING
C631 B.n36 VGND 0.07767f **FLOATING
C632 B.n37 VGND 0.48205f **FLOATING
C633 B.n38 VGND 0.02167f **FLOATING
C634 B.n39 VGND 0.01219f **FLOATING
C635 B.n40 VGND 0.01594f **FLOATING
C636 B.t7 VGND 0.09767f **FLOATING
C637 B.n41 VGND 0.00632f **FLOATING
C638 B.n43 VGND 0.01594f **FLOATING
C639 B.n44 VGND 0.01594f **FLOATING
C640 B.n45 VGND 0.01185f **FLOATING
C641 B.n46 VGND 0.01084f **FLOATING
C642 B.n47 VGND 0.0352f **FLOATING
C643 B.n48 VGND 0.01084f **FLOATING
C644 B.n49 VGND 0.01117f **FLOATING
C645 B.n50 VGND 0.04655f **FLOATING
C646 B.n51 VGND 0.02167f **FLOATING
C647 B.n52 VGND 0.02167f **FLOATING
C648 B.n53 VGND 0.01084f **FLOATING
C649 B.n54 VGND 0.02167f **FLOATING
C650 B.n55 VGND 0.01219f **FLOATING
C651 B.n56 VGND 0.01594f **FLOATING
C652 B.n57 VGND 0.01084f **FLOATING
C653 B.n58 VGND 0.01219f **FLOATING
C654 B.n59 VGND 0.01594f **FLOATING
C655 B.n60 VGND 0.01084f **FLOATING
C656 B.n61 VGND 0.01219f **FLOATING
C657 B.n62 VGND 0.02167f **FLOATING
C658 B.n63 VGND 0.02167f **FLOATING
C659 B.n64 VGND 0.01219f **FLOATING
C660 B.n65 VGND 0.01084f **FLOATING
C661 B.n66 VGND 0.01594f **FLOATING
C662 B.t6 VGND 0.09767f **FLOATING
C663 B.n68 VGND 0.19535f **FLOATING
C664 B.n69 VGND 0.0063f **FLOATING
C665 B.n70 VGND 0.03759f **FLOATING
C666 B.n71 VGND 0.09055f **FLOATING
C667 B.n72 VGND 0.09404f **FLOATING
C668 B.n73 VGND 0.14411f **FLOATING
C669 B.n74 VGND 0.0161f **FLOATING
C670 B.n75 VGND 0.30792f **FLOATING
C671 B.n76 VGND 0.38222f **FLOATING
C672 EN.t0 VGND 0.04093f **FLOATING
C673 EN.t1 VGND 0.04083f **FLOATING
C674 EN.n0 VGND 0.1622f **FLOATING
C675 EN.t2 VGND 0.04083f **FLOATING
C676 EN.n1 VGND 0.05327f **FLOATING
C677 EN.t3 VGND 0.04083f **FLOATING
C678 EN.n2 VGND 0.23632f **FLOATING
C679 EN.t4 VGND 0.04083f **FLOATING
C680 EN.n3 VGND 0.23549f **FLOATING
C681 EN.t5 VGND 0.04083f **FLOATING
C682 EN.n4 VGND 0.05327f **FLOATING
C683 EN.t6 VGND 0.04083f **FLOATING
C684 EN.n5 VGND 0.05327f **FLOATING
C685 EN.t7 VGND 0.04083f **FLOATING
C686 EN.n6 VGND 0.07418f **FLOATING
