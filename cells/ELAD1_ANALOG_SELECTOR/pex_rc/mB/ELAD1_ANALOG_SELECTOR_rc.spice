* SPICE3 file created from ELAD1_ANALOG_SELECTOR.ext - technology: sky130A

X0 ELAD1_INV_3/Y EN_PC VDPWR VDPWR sky130_fd_pr__pfet_01v8 ad=0.3 pd=2.6 as=0.3 ps=2.6 w=1 l=0.15
X1 ELAD1_INV_3/Y EN_PC VGND VGND sky130_fd_pr__nfet_01v8 ad=0.195 pd=1.9 as=0.195 ps=1.9 w=0.65 l=0.15
X2 ELAD1_INV_4/Y EN_PG VDPWR VDPWR sky130_fd_pr__pfet_01v8 ad=0.3 pd=2.6 as=1.5 ps=13 w=1 l=0.15
X3 ELAD1_INV_4/Y EN_PG VGND VGND sky130_fd_pr__nfet_01v8 ad=0.19502 pd=1.905 as=2.835 ps=29.1 w=0.65 l=0.15
X4 VINM_C EN_PC UA2 VGND sky130_fd_pr__nfet_01v8 ad=0.3 pd=2.6 as=0.3 ps=2.6 w=1 l=0.15
X5 VINM_C ELAD1_INV_3/Y UA2 VDPWR sky130_fd_pr__pfet_01v8 ad=0.6 pd=4.6 as=0.6 ps=4.6 w=2 l=0.15
X6 REF_C EN_MC UA3 VGND sky130_fd_pr__nfet_01v8 ad=1.526 pd=12.24 as=3.6 ps=23.2 w=1 l=0.15
X7 REF_C ELAD1_INV_1/Y UA3 VDPWR sky130_fd_pr__pfet_01v8 ad=3.6 pd=18.6 as=11.1 ps=69.8 w=2 l=0.15
X8 REF_G EN_MG UA3 VGND sky130_fd_pr__nfet_01v8 ad=1.526 pd=12.24 as=0 ps=0 w=1 l=0.15
X9 REF_G ELAD1_INV_0/Y UA3 VDPWR sky130_fd_pr__pfet_01v8 ad=3.6 pd=18.6 as=0 ps=0 w=2 l=0.15
X10 SUBI EN_N UA2 VGND sky130_fd_pr__nfet_01v8 ad=0.6 pd=5.2 as=1.5 ps=13 w=1 l=0.15
X11 SUBI ELAD1_INV_2/Y UA2 VDPWR sky130_fd_pr__pfet_01v8 ad=1.2 pd=9.2 as=3 ps=23 w=2 l=0.15
X12 VQUIET_B EN_N UA1 VGND sky130_fd_pr__nfet_01v8 ad=0.426 pd=4.04 as=1.2 ps=10.4 w=1 l=0.15
X13 VQUIET_B ELAD1_INV_2/Y UA1 VDPWR sky130_fd_pr__pfet_01v8 ad=0.6 pd=4.6 as=2.4 ps=18.4 w=2 l=0.15
X14 VINM_G EN_PG UA2 VGND sky130_fd_pr__nfet_01v8 ad=0.426 pd=4.04 as=0 ps=0 w=1 l=0.15
X15 VINM_G ELAD1_INV_4/Y UA2 VDPWR sky130_fd_pr__pfet_01v8 ad=0.6 pd=4.6 as=0 ps=0 w=2 l=0.15
X16 OUT_C EN_MC UA2 VGND sky130_fd_pr__nfet_01v8 ad=1.4 pd=10.8 as=0 ps=0 w=1 l=0.15
X17 OUT_C ELAD1_INV_1/Y UA2 VDPWR sky130_fd_pr__pfet_01v8 ad=3.6 pd=18.6 as=0 ps=0 w=2 l=0.15
X18 OUT_G EN_MG UA2 VGND sky130_fd_pr__nfet_01v8 ad=1.4 pd=10.8 as=0 ps=0 w=1 l=0.15
X19 OUT_G ELAD1_INV_0/Y UA2 VDPWR sky130_fd_pr__pfet_01v8 ad=3.6 pd=18.6 as=0 ps=0 w=2 l=0.15
X20 SUBI EN_N UA0 VGND sky130_fd_pr__nfet_01v8 ad=0 pd=0 as=4.3 ps=26.6 w=1 l=0.15
X21 SUBI ELAD1_INV_2/Y UA0 VDPWR sky130_fd_pr__pfet_01v8 ad=0 pd=0 as=13.8 ps=85.4 w=2 l=0.15
X22 VQUIET_A EN_N UA1 VGND sky130_fd_pr__nfet_01v8 ad=0.426 pd=4.04 as=0 ps=0 w=1 l=0.15
X23 VQUIET_A ELAD1_INV_2/Y UA1 VDPWR sky130_fd_pr__pfet_01v8 ad=0.6 pd=4.6 as=0 ps=0 w=2 l=0.15
X24 VGND CLR_PC VINP_C VGND sky130_fd_pr__nfet_01v8 ad=0.126 pd=1.44 as=0.126 ps=1.44 w=0.42 l=1
X25 VGND CLR_N VQUIET_B VGND sky130_fd_pr__nfet_01v8 ad=0 pd=0 as=0 ps=0 w=0.42 l=1
X26 VGND CLR_N VQUIET_A VGND sky130_fd_pr__nfet_01v8 ad=0 pd=0 as=0 ps=0 w=0.42 l=1
X27 VGND CLR_PC VINM_C VGND sky130_fd_pr__nfet_01v8 ad=0 pd=0 as=0.426 ps=4.04 w=0.42 l=1
X28 VGND CLR_PC VBIAS_C VGND sky130_fd_pr__nfet_01v8 ad=0 pd=0 as=1.226 ps=9.64 w=0.42 l=1
X29 VGND CLR_PG VINM_G VGND sky130_fd_pr__nfet_01v8 ad=0 pd=0 as=0 ps=0 w=0.42 l=1
X30 VGND CLR_PG VBIAS_G VGND sky130_fd_pr__nfet_01v8 ad=0 pd=0 as=1.226 ps=9.64 w=0.42 l=1
X31 VGND CLR_MC REF_C VGND sky130_fd_pr__nfet_01v8 ad=0 pd=0 as=0 ps=0 w=0.42 l=1
X32 VGND CLR_MG REF_G VGND sky130_fd_pr__nfet_01v8 ad=0 pd=0 as=0 ps=0 w=0.42 l=1
X33 VGND CLR_PG VINP_G VGND sky130_fd_pr__nfet_01v8 ad=0 pd=0 as=0.426 ps=4.04 w=0.42 l=1
X34 D1_G ELAD1_INV_4/Y UA3 VDPWR sky130_fd_pr__pfet_01v8_lvt ad=0.75 pd=3.5 as=0.9 ps=6.6 w=3 l=0.35
X35 UA3 ELAD1_INV_4/Y D1_G VDPWR sky130_fd_pr__pfet_01v8_lvt ad=0.75 pd=3.5 as=0.75 ps=3.5 w=3 l=0.35
X36 UA3 ELAD1_INV_4/Y D1_G VDPWR sky130_fd_pr__pfet_01v8_lvt ad=0.9 pd=6.6 as=0.75 ps=3.5 w=3 l=0.35
X37 D1_G ELAD1_INV_4/Y UA3 VDPWR sky130_fd_pr__pfet_01v8_lvt ad=0.75 pd=3.5 as=0.75 ps=3.5 w=3 l=0.35
X38 UA3 EN_PG D1_G VGND sky130_fd_pr__nfet_01v8_lvt ad=0.25 pd=1.5 as=0.3 ps=2.6 w=1 l=0.15
X39 UA3 EN_PG D1_G VGND sky130_fd_pr__nfet_01v8_lvt ad=0.25 pd=1.5 as=0.25 ps=1.5 w=1 l=0.15
X40 D1_G EN_PG UA3 VGND sky130_fd_pr__nfet_01v8_lvt ad=0.3 pd=2.6 as=0.25 ps=1.5 w=1 l=0.15
X41 D1_G EN_PG UA3 VGND sky130_fd_pr__nfet_01v8_lvt ad=0.25 pd=1.5 as=0.25 ps=1.5 w=1 l=0.15
X42 VBIAS_C ELAD1_INV_3/Y UA0 VDPWR sky130_fd_pr__pfet_01v8_lvt ad=3 pd=14 as=0 ps=0 w=3 l=0.35
X43 UA0 ELAD1_INV_3/Y VBIAS_C VDPWR sky130_fd_pr__pfet_01v8_lvt ad=0 pd=0 as=0 ps=0 w=3 l=0.35
X44 UA0 ELAD1_INV_3/Y VBIAS_C VDPWR sky130_fd_pr__pfet_01v8_lvt ad=0 pd=0 as=0 ps=0 w=3 l=0.35
X45 VBIAS_C ELAD1_INV_3/Y UA0 VDPWR sky130_fd_pr__pfet_01v8_lvt ad=0 pd=0 as=0 ps=0 w=3 l=0.35
X46 UA0 EN_PC VBIAS_C VGND sky130_fd_pr__nfet_01v8_lvt ad=0 pd=0 as=0 ps=0 w=1 l=0.15
X47 UA0 EN_PC VBIAS_C VGND sky130_fd_pr__nfet_01v8_lvt ad=0 pd=0 as=0 ps=0 w=1 l=0.15
X48 VBIAS_C EN_PC UA0 VGND sky130_fd_pr__nfet_01v8_lvt ad=0 pd=0 as=0 ps=0 w=1 l=0.15
X49 VBIAS_C EN_PC UA0 VGND sky130_fd_pr__nfet_01v8_lvt ad=0 pd=0 as=0 ps=0 w=1 l=0.15
X50 REF_G ELAD1_INV_0/Y UA0 VDPWR sky130_fd_pr__pfet_01v8_lvt ad=0 pd=0 as=0 ps=0 w=3 l=0.35
X51 UA0 ELAD1_INV_0/Y REF_G VDPWR sky130_fd_pr__pfet_01v8_lvt ad=0 pd=0 as=0 ps=0 w=3 l=0.35
X52 UA0 ELAD1_INV_0/Y REF_G VDPWR sky130_fd_pr__pfet_01v8_lvt ad=0 pd=0 as=0 ps=0 w=3 l=0.35
X53 REF_G ELAD1_INV_0/Y UA0 VDPWR sky130_fd_pr__pfet_01v8_lvt ad=0 pd=0 as=0 ps=0 w=3 l=0.35
X54 UA0 EN_MG REF_G VGND sky130_fd_pr__nfet_01v8_lvt ad=0 pd=0 as=0 ps=0 w=1 l=0.15
X55 UA0 EN_MG REF_G VGND sky130_fd_pr__nfet_01v8_lvt ad=0 pd=0 as=0 ps=0 w=1 l=0.15
X56 REF_G EN_MG UA0 VGND sky130_fd_pr__nfet_01v8_lvt ad=0 pd=0 as=0 ps=0 w=1 l=0.15
X57 REF_G EN_MG UA0 VGND sky130_fd_pr__nfet_01v8_lvt ad=0 pd=0 as=0 ps=0 w=1 l=0.15
X58 REF_C ELAD1_INV_1/Y UA0 VDPWR sky130_fd_pr__pfet_01v8_lvt ad=0 pd=0 as=0 ps=0 w=3 l=0.35
X59 UA0 ELAD1_INV_1/Y REF_C VDPWR sky130_fd_pr__pfet_01v8_lvt ad=0 pd=0 as=0 ps=0 w=3 l=0.35
X60 UA0 ELAD1_INV_1/Y REF_C VDPWR sky130_fd_pr__pfet_01v8_lvt ad=0 pd=0 as=0 ps=0 w=3 l=0.35
X61 REF_C ELAD1_INV_1/Y UA0 VDPWR sky130_fd_pr__pfet_01v8_lvt ad=0 pd=0 as=0 ps=0 w=3 l=0.35
X62 UA0 EN_MC REF_C VGND sky130_fd_pr__nfet_01v8_lvt ad=0 pd=0 as=0 ps=0 w=1 l=0.15
X63 UA0 EN_MC REF_C VGND sky130_fd_pr__nfet_01v8_lvt ad=0 pd=0 as=0 ps=0 w=1 l=0.15
X64 REF_C EN_MC UA0 VGND sky130_fd_pr__nfet_01v8_lvt ad=0 pd=0 as=0 ps=0 w=1 l=0.15
X65 REF_C EN_MC UA0 VGND sky130_fd_pr__nfet_01v8_lvt ad=0 pd=0 as=0 ps=0 w=1 l=0.15
X66 ELAD1_TSW_0/ELAD1_TGA_1/B ELAD1_INV_2/Y VGND VGND sky130_fd_pr__nfet_01v8 ad=0.3 pd=2.6 as=0.3 ps=2.6 w=1 l=0.15
X67 OUT_A ELAD1_INV_2/Y ELAD1_TSW_0/ELAD1_TGA_1/B VDPWR sky130_fd_pr__pfet_01v8_lvt ad=3 pd=14 as=6.3 ps=34.2 w=3 l=0.35
X68 ELAD1_TSW_0/ELAD1_TGA_1/B ELAD1_INV_2/Y OUT_A VDPWR sky130_fd_pr__pfet_01v8_lvt ad=0 pd=0 as=0 ps=0 w=3 l=0.35
X69 ELAD1_TSW_0/ELAD1_TGA_1/B ELAD1_INV_2/Y OUT_A VDPWR sky130_fd_pr__pfet_01v8_lvt ad=0 pd=0 as=0 ps=0 w=3 l=0.35
X70 OUT_A ELAD1_INV_2/Y ELAD1_TSW_0/ELAD1_TGA_1/B VDPWR sky130_fd_pr__pfet_01v8_lvt ad=0 pd=0 as=0 ps=0 w=3 l=0.35
X71 ELAD1_TSW_0/ELAD1_TGA_1/B EN_N OUT_A VGND sky130_fd_pr__nfet_01v8_lvt ad=2.4 pd=16.8 as=1.1 ps=8.2 w=1 l=0.15
X72 ELAD1_TSW_0/ELAD1_TGA_1/B EN_N OUT_A VGND sky130_fd_pr__nfet_01v8_lvt ad=0 pd=0 as=0 ps=0 w=1 l=0.15
X73 OUT_A EN_N ELAD1_TSW_0/ELAD1_TGA_1/B VGND sky130_fd_pr__nfet_01v8_lvt ad=0 pd=0 as=0 ps=0 w=1 l=0.15
X74 OUT_A EN_N ELAD1_TSW_0/ELAD1_TGA_1/B VGND sky130_fd_pr__nfet_01v8_lvt ad=0 pd=0 as=0 ps=0 w=1 l=0.15
X75 ELAD1_TSW_0/ELAD1_TGA_1/B ELAD1_INV_2/Y UA3 VDPWR sky130_fd_pr__pfet_01v8_lvt ad=0 pd=0 as=0 ps=0 w=3 l=0.35
X76 UA3 ELAD1_INV_2/Y ELAD1_TSW_0/ELAD1_TGA_1/B VDPWR sky130_fd_pr__pfet_01v8_lvt ad=0 pd=0 as=0 ps=0 w=3 l=0.35
X77 UA3 ELAD1_INV_2/Y ELAD1_TSW_0/ELAD1_TGA_1/B VDPWR sky130_fd_pr__pfet_01v8_lvt ad=0 pd=0 as=0 ps=0 w=3 l=0.35
X78 ELAD1_TSW_0/ELAD1_TGA_1/B ELAD1_INV_2/Y UA3 VDPWR sky130_fd_pr__pfet_01v8_lvt ad=0 pd=0 as=0 ps=0 w=3 l=0.35
X79 UA3 EN_N ELAD1_TSW_0/ELAD1_TGA_1/B VGND sky130_fd_pr__nfet_01v8_lvt ad=0 pd=0 as=0 ps=0 w=1 l=0.15
X80 UA3 EN_N ELAD1_TSW_0/ELAD1_TGA_1/B VGND sky130_fd_pr__nfet_01v8_lvt ad=0 pd=0 as=0 ps=0 w=1 l=0.15
X81 ELAD1_TSW_0/ELAD1_TGA_1/B EN_N UA3 VGND sky130_fd_pr__nfet_01v8_lvt ad=0 pd=0 as=0 ps=0 w=1 l=0.15
X82 ELAD1_TSW_0/ELAD1_TGA_1/B EN_N UA3 VGND sky130_fd_pr__nfet_01v8_lvt ad=0 pd=0 as=0 ps=0 w=1 l=0.15
X83 OUT_G ELAD1_INV_0/Y UA4 VDPWR sky130_fd_pr__pfet_01v8_lvt ad=0 pd=0 as=16.5 ps=101 w=3 l=0.35
X84 UA4 ELAD1_INV_0/Y OUT_G VDPWR sky130_fd_pr__pfet_01v8_lvt ad=0 pd=0 as=0 ps=0 w=3 l=0.35
X85 UA4 ELAD1_INV_0/Y OUT_G VDPWR sky130_fd_pr__pfet_01v8_lvt ad=0 pd=0 as=0 ps=0 w=3 l=0.35
X86 OUT_G ELAD1_INV_0/Y UA4 VDPWR sky130_fd_pr__pfet_01v8_lvt ad=0 pd=0 as=0 ps=0 w=3 l=0.35
X87 UA4 EN_MG OUT_G VGND sky130_fd_pr__nfet_01v8_lvt ad=5 pd=30 as=0 ps=0 w=1 l=0.15
X88 UA4 EN_MG OUT_G VGND sky130_fd_pr__nfet_01v8_lvt ad=0 pd=0 as=0 ps=0 w=1 l=0.15
X89 OUT_G EN_MG UA4 VGND sky130_fd_pr__nfet_01v8_lvt ad=0 pd=0 as=0 ps=0 w=1 l=0.15
X90 OUT_G EN_MG UA4 VGND sky130_fd_pr__nfet_01v8_lvt ad=0 pd=0 as=0 ps=0 w=1 l=0.15
X91 ELAD1_TSW_1/ELAD1_TGA_1/B ELAD1_INV_2/Y VGND VGND sky130_fd_pr__nfet_01v8 ad=2.4 pd=16.8 as=0 ps=0 w=1 l=0.15
X92 OUT_B ELAD1_INV_2/Y ELAD1_TSW_1/ELAD1_TGA_1/B VDPWR sky130_fd_pr__pfet_01v8_lvt ad=3 pd=14 as=6.3 ps=34.2 w=3 l=0.35
X93 ELAD1_TSW_1/ELAD1_TGA_1/B ELAD1_INV_2/Y OUT_B VDPWR sky130_fd_pr__pfet_01v8_lvt ad=0 pd=0 as=0 ps=0 w=3 l=0.35
X94 ELAD1_TSW_1/ELAD1_TGA_1/B ELAD1_INV_2/Y OUT_B VDPWR sky130_fd_pr__pfet_01v8_lvt ad=0 pd=0 as=0 ps=0 w=3 l=0.35
X95 OUT_B ELAD1_INV_2/Y ELAD1_TSW_1/ELAD1_TGA_1/B VDPWR sky130_fd_pr__pfet_01v8_lvt ad=0 pd=0 as=0 ps=0 w=3 l=0.35
X96 ELAD1_TSW_1/ELAD1_TGA_1/B EN_N OUT_B VGND sky130_fd_pr__nfet_01v8_lvt ad=0 pd=0 as=1.1 ps=8.2 w=1 l=0.15
X97 ELAD1_TSW_1/ELAD1_TGA_1/B EN_N OUT_B VGND sky130_fd_pr__nfet_01v8_lvt ad=0 pd=0 as=0 ps=0 w=1 l=0.15
X98 OUT_B EN_N ELAD1_TSW_1/ELAD1_TGA_1/B VGND sky130_fd_pr__nfet_01v8_lvt ad=0 pd=0 as=0 ps=0 w=1 l=0.15
X99 OUT_B EN_N ELAD1_TSW_1/ELAD1_TGA_1/B VGND sky130_fd_pr__nfet_01v8_lvt ad=0 pd=0 as=0 ps=0 w=1 l=0.15
X100 ELAD1_TSW_1/ELAD1_TGA_1/B ELAD1_INV_2/Y UA4 VDPWR sky130_fd_pr__pfet_01v8_lvt ad=0 pd=0 as=0 ps=0 w=3 l=0.35
X101 UA4 ELAD1_INV_2/Y ELAD1_TSW_1/ELAD1_TGA_1/B VDPWR sky130_fd_pr__pfet_01v8_lvt ad=0 pd=0 as=0 ps=0 w=3 l=0.35
X102 UA4 ELAD1_INV_2/Y ELAD1_TSW_1/ELAD1_TGA_1/B VDPWR sky130_fd_pr__pfet_01v8_lvt ad=0 pd=0 as=0 ps=0 w=3 l=0.35
X103 ELAD1_TSW_1/ELAD1_TGA_1/B ELAD1_INV_2/Y UA4 VDPWR sky130_fd_pr__pfet_01v8_lvt ad=0 pd=0 as=0 ps=0 w=3 l=0.35
X104 UA4 EN_N ELAD1_TSW_1/ELAD1_TGA_1/B VGND sky130_fd_pr__nfet_01v8_lvt ad=0 pd=0 as=0 ps=0 w=1 l=0.15
X105 UA4 EN_N ELAD1_TSW_1/ELAD1_TGA_1/B VGND sky130_fd_pr__nfet_01v8_lvt ad=0 pd=0 as=0 ps=0 w=1 l=0.15
X106 ELAD1_TSW_1/ELAD1_TGA_1/B EN_N UA4 VGND sky130_fd_pr__nfet_01v8_lvt ad=0 pd=0 as=0 ps=0 w=1 l=0.15
X107 ELAD1_TSW_1/ELAD1_TGA_1/B EN_N UA4 VGND sky130_fd_pr__nfet_01v8_lvt ad=0 pd=0 as=0 ps=0 w=1 l=0.15
X108 OUT_C ELAD1_INV_1/Y UA4 VDPWR sky130_fd_pr__pfet_01v8_lvt ad=0 pd=0 as=0 ps=0 w=3 l=0.35
X109 UA4 ELAD1_INV_1/Y OUT_C VDPWR sky130_fd_pr__pfet_01v8_lvt ad=0 pd=0 as=0 ps=0 w=3 l=0.35
X110 UA4 ELAD1_INV_1/Y OUT_C VDPWR sky130_fd_pr__pfet_01v8_lvt ad=0 pd=0 as=0 ps=0 w=3 l=0.35
X111 OUT_C ELAD1_INV_1/Y UA4 VDPWR sky130_fd_pr__pfet_01v8_lvt ad=0 pd=0 as=0 ps=0 w=3 l=0.35
X112 UA4 EN_MC OUT_C VGND sky130_fd_pr__nfet_01v8_lvt ad=0 pd=0 as=0 ps=0 w=1 l=0.15
X113 UA4 EN_MC OUT_C VGND sky130_fd_pr__nfet_01v8_lvt ad=0 pd=0 as=0 ps=0 w=1 l=0.15
X114 OUT_C EN_MC UA4 VGND sky130_fd_pr__nfet_01v8_lvt ad=0 pd=0 as=0 ps=0 w=1 l=0.15
X115 OUT_C EN_MC UA4 VGND sky130_fd_pr__nfet_01v8_lvt ad=0 pd=0 as=0 ps=0 w=1 l=0.15
X116 VINP_C EN_PC UA1 VGND sky130_fd_pr__nfet_01v8 ad=0.426 pd=4.04 as=0 ps=0 w=1 l=0.15
X117 VINP_C ELAD1_INV_3/Y UA1 VDPWR sky130_fd_pr__pfet_01v8 ad=0.6 pd=4.6 as=0 ps=0 w=2 l=0.15
X118 D2_C ELAD1_INV_3/Y UA4 VDPWR sky130_fd_pr__pfet_01v8_lvt ad=3 pd=14 as=0 ps=0 w=3 l=0.35
X119 UA4 ELAD1_INV_3/Y D2_C VDPWR sky130_fd_pr__pfet_01v8_lvt ad=0 pd=0 as=0 ps=0 w=3 l=0.35
X120 UA4 ELAD1_INV_3/Y D2_C VDPWR sky130_fd_pr__pfet_01v8_lvt ad=0 pd=0 as=0 ps=0 w=3 l=0.35
X121 D2_C ELAD1_INV_3/Y UA4 VDPWR sky130_fd_pr__pfet_01v8_lvt ad=0 pd=0 as=0 ps=0 w=3 l=0.35
X122 UA4 EN_PC D2_C VGND sky130_fd_pr__nfet_01v8_lvt ad=0 pd=0 as=1.1 ps=8.2 w=1 l=0.15
X123 UA4 EN_PC D2_C VGND sky130_fd_pr__nfet_01v8_lvt ad=0 pd=0 as=0 ps=0 w=1 l=0.15
X124 D2_C EN_PC UA4 VGND sky130_fd_pr__nfet_01v8_lvt ad=0 pd=0 as=0 ps=0 w=1 l=0.15
X125 D2_C EN_PC UA4 VGND sky130_fd_pr__nfet_01v8_lvt ad=0 pd=0 as=0 ps=0 w=1 l=0.15
X126 VINP_G EN_PG UA1 VGND sky130_fd_pr__nfet_01v8 ad=0 pd=0 as=0 ps=0 w=1 l=0.15
X127 VINP_G ELAD1_INV_4/Y UA1 VDPWR sky130_fd_pr__pfet_01v8 ad=0.6 pd=4.6 as=0 ps=0 w=2 l=0.15
X128 D1_C ELAD1_INV_3/Y UA3 VDPWR sky130_fd_pr__pfet_01v8_lvt ad=3 pd=14 as=0 ps=0 w=3 l=0.35
X129 UA3 ELAD1_INV_3/Y D1_C VDPWR sky130_fd_pr__pfet_01v8_lvt ad=0 pd=0 as=0 ps=0 w=3 l=0.35
X130 UA3 ELAD1_INV_3/Y D1_C VDPWR sky130_fd_pr__pfet_01v8_lvt ad=0 pd=0 as=0 ps=0 w=3 l=0.35
X131 D1_C ELAD1_INV_3/Y UA3 VDPWR sky130_fd_pr__pfet_01v8_lvt ad=0 pd=0 as=0 ps=0 w=3 l=0.35
X132 UA3 EN_PC D1_C VGND sky130_fd_pr__nfet_01v8_lvt ad=0 pd=0 as=1.1 ps=8.2 w=1 l=0.15
X133 UA3 EN_PC D1_C VGND sky130_fd_pr__nfet_01v8_lvt ad=0 pd=0 as=0 ps=0 w=1 l=0.15
X134 D1_C EN_PC UA3 VGND sky130_fd_pr__nfet_01v8_lvt ad=0 pd=0 as=0 ps=0 w=1 l=0.15
X135 D1_C EN_PC UA3 VGND sky130_fd_pr__nfet_01v8_lvt ad=0 pd=0 as=0 ps=0 w=1 l=0.15
X136 VBIAS_G ELAD1_INV_4/Y UA0 VDPWR sky130_fd_pr__pfet_01v8_lvt ad=3 pd=14 as=0 ps=0 w=3 l=0.35
X137 UA0 ELAD1_INV_4/Y VBIAS_G VDPWR sky130_fd_pr__pfet_01v8_lvt ad=0 pd=0 as=0 ps=0 w=3 l=0.35
X138 UA0 ELAD1_INV_4/Y VBIAS_G VDPWR sky130_fd_pr__pfet_01v8_lvt ad=0 pd=0 as=0 ps=0 w=3 l=0.35
X139 VBIAS_G ELAD1_INV_4/Y UA0 VDPWR sky130_fd_pr__pfet_01v8_lvt ad=0 pd=0 as=0 ps=0 w=3 l=0.35
X140 UA0 EN_PG VBIAS_G VGND sky130_fd_pr__nfet_01v8_lvt ad=0 pd=0 as=0 ps=0 w=1 l=0.15
X141 UA0 EN_PG VBIAS_G VGND sky130_fd_pr__nfet_01v8_lvt ad=0 pd=0 as=0 ps=0 w=1 l=0.15
X142 VBIAS_G EN_PG UA0 VGND sky130_fd_pr__nfet_01v8_lvt ad=0 pd=0 as=0 ps=0 w=1 l=0.15
X143 VBIAS_G EN_PG UA0 VGND sky130_fd_pr__nfet_01v8_lvt ad=0 pd=0 as=0 ps=0 w=1 l=0.15
X144 D2_G ELAD1_INV_4/Y UA4 VDPWR sky130_fd_pr__pfet_01v8_lvt ad=3 pd=14 as=0 ps=0 w=3 l=0.35
X145 UA4 ELAD1_INV_4/Y D2_G VDPWR sky130_fd_pr__pfet_01v8_lvt ad=0 pd=0 as=0 ps=0 w=3 l=0.35
X146 UA4 ELAD1_INV_4/Y D2_G VDPWR sky130_fd_pr__pfet_01v8_lvt ad=0 pd=0 as=0 ps=0 w=3 l=0.35
X147 D2_G ELAD1_INV_4/Y UA4 VDPWR sky130_fd_pr__pfet_01v8_lvt ad=0 pd=0 as=0 ps=0 w=3 l=0.35
X148 UA4 EN_PG D2_G VGND sky130_fd_pr__nfet_01v8_lvt ad=0 pd=0 as=1.1 ps=8.2 w=1 l=0.15
X149 UA4 EN_PG D2_G VGND sky130_fd_pr__nfet_01v8_lvt ad=0 pd=0 as=0 ps=0 w=1 l=0.15
X150 D2_G EN_PG UA4 VGND sky130_fd_pr__nfet_01v8_lvt ad=0 pd=0 as=0 ps=0 w=1 l=0.15
X151 D2_G EN_PG UA4 VGND sky130_fd_pr__nfet_01v8_lvt ad=0 pd=0 as=0 ps=0 w=1 l=0.15
X152 ELAD1_INV_0/Y EN_MG VDPWR VDPWR sky130_fd_pr__pfet_01v8 ad=0.3 pd=2.6 as=0 ps=0 w=1 l=0.15
X153 ELAD1_INV_0/Y EN_MG VGND VGND sky130_fd_pr__nfet_01v8 ad=0.19502 pd=1.905 as=0 ps=0 w=0.65 l=0.15
X154 ELAD1_INV_1/Y EN_MC VDPWR VDPWR sky130_fd_pr__pfet_01v8 ad=0.3 pd=2.6 as=0 ps=0 w=1 l=0.15
X155 ELAD1_INV_1/Y EN_MC VGND VGND sky130_fd_pr__nfet_01v8 ad=0.19502 pd=1.905 as=0 ps=0 w=0.65 l=0.15
X156 ELAD1_INV_2/Y EN_N VDPWR VDPWR sky130_fd_pr__pfet_01v8 ad=0.3 pd=2.6 as=0 ps=0 w=1 l=0.15
X157 ELAD1_INV_2/Y EN_N VGND VGND sky130_fd_pr__nfet_01v8 ad=0.19502 pd=1.905 as=0 ps=0 w=0.65 l=0.15
C0 UA4 VINP_G 0
C1 ELAD1_INV_1/Y VINP_G 0.03776f
C2 OUT_B D2_G 1.59308f
C3 UA0 ELAD1_INV_2/Y 0.18177f
C4 OUT_A EN_PG 0.61635f
C5 EN_PG VINP_C 0.14964f
C6 UA3 REF_C 1.081f
C7 ELAD1_INV_3/Y EN_PG 0.64942f
C8 VINM_C ELAD1_TSW_0/ELAD1_TGA_1/B 0
C9 VINM_C EN_MC 0.09617f
C10 VINM_C ELAD1_TSW_1/ELAD1_TGA_1/B 0.00114f
C11 UA1 UA4 0.00176f
C12 UA0 VDPWR 4.274f
C13 UA1 ELAD1_INV_1/Y 0.02914f
C14 VBIAS_G OUT_A 0.10537f
C15 VBIAS_G VINP_C 2.18078f
C16 ELAD1_INV_4/Y REF_G 0.14368f
C17 VBIAS_G ELAD1_INV_3/Y 0.44617f
C18 D1_C SUBI 0.00478f
C19 EN_MG OUT_A 0.17135f
C20 ELAD1_INV_0/Y CLR_PC 0.08306f
C21 EN_MG VINP_C 0.12918f
C22 VINM_G EN_PG 0.44293f
C23 UA0 CLR_PG 0.05222f
C24 EN_MC OUT_G 0.19984f
C25 EN_MG ELAD1_INV_3/Y 0.16375f
C26 EN_PG VQUIET_A 0.08587f
C27 UA3 EN_PC 0.43533f
C28 D2_G EN_MC 0
C29 VQUIET_B ELAD1_TSW_0/ELAD1_TGA_1/B 0
C30 EN_MC VQUIET_B 0.18526f
C31 REF_G UA2 0
C32 UA0 REF_C 2.95496f
C33 VINM_G VBIAS_G 0.04236f
C34 CLR_MG REF_G 0.07427f
C35 D1_G ELAD1_TSW_0/ELAD1_TGA_1/B 0.01923f
C36 CLR_N VBIAS_C 0.05877f
C37 UA0 OUT_C 0.16802f
C38 D1_G EN_MC 0.02666f
C39 OUT_B ELAD1_INV_3/Y 0.07116f
C40 VBIAS_G VQUIET_A 0.04549f
C41 VINP_G REF_G 0.03928f
C42 SUBI VBIAS_C 0
C43 EN_MG VINM_G 0.10905f
C44 ELAD1_INV_4/Y UA2 0.42216f
C45 CLR_MG ELAD1_INV_4/Y 0.02898f
C46 CLR_MC CLR_PC 0.61643f
C47 EN_MG VQUIET_A 0.09315f
C48 VINM_C D1_C 0
C49 ELAD1_INV_4/Y VINP_G 0.12019f
C50 ELAD1_INV_0/Y UA3 0.56093f
C51 UA0 EN_PC 0.47196f
C52 EN_N EN_PG 1.16711f
C53 ELAD1_TSW_0/ELAD1_TGA_1/B VINP_C 0
C54 CLR_MG UA2 0
C55 OUT_A ELAD1_TSW_0/ELAD1_TGA_1/B 2.99506f
C56 D2_C EN_PG 0.091f
C57 EN_MC OUT_A 0.45543f
C58 ELAD1_INV_1/Y CLR_PC 0.21506f
C59 EN_MC VINP_C 0.13228f
C60 UA1 ELAD1_INV_4/Y 0.14556f
C61 ELAD1_INV_3/Y ELAD1_TSW_0/ELAD1_TGA_1/B 0
C62 EN_MC ELAD1_INV_3/Y 0.14906f
C63 D1_C OUT_G 0.03898f
C64 ELAD1_TSW_1/ELAD1_TGA_1/B ELAD1_INV_3/Y 0.03956f
C65 VINP_G UA2 0.05387f
C66 VINM_C VBIAS_C 0.04118f
C67 CLR_MG VINP_G 0.01078f
C68 EN_N VBIAS_G 0.15467f
C69 D2_G D1_C 0
C70 D1_C VQUIET_B 0
C71 EN_N EN_MG 0.27866f
C72 UA1 UA2 1.21847f
C73 EN_MG D2_C 0.02812f
C74 VINM_G ELAD1_TSW_0/ELAD1_TGA_1/B 0
C75 UA0 ELAD1_INV_0/Y 0.76891f
C76 UA1 CLR_MG 0
C77 VINM_G EN_MC 0.10838f
C78 SUBI CLR_N 0.00124f
C79 ELAD1_TSW_1/ELAD1_TGA_1/B VINM_G 0
C80 EN_PG ELAD1_INV_2/Y 0.53114f
C81 ELAD1_TSW_0/ELAD1_TGA_1/B VQUIET_A 0
C82 EN_MC VQUIET_A 0.09636f
C83 UA1 VINP_G 0.85897f
C84 OUT_B EN_N 0.65133f
C85 OUT_B D2_C 0.21287f
C86 UA3 ELAD1_INV_1/Y 0.74405f
C87 VQUIET_B VBIAS_C 0.04392f
C88 VBIAS_G ELAD1_INV_2/Y 0.12693f
C89 EN_PG VDPWR 0.95856f
C90 D1_G VBIAS_C 0.14113f
C91 REF_G CLR_PC 0
C92 D1_C VINP_C 0
C93 EN_MG ELAD1_INV_2/Y 4.01829f
C94 UA0 CLR_MC 0.06566f
C95 VBIAS_G VDPWR 0.81626f
C96 EN_PG CLR_PG 0.03492f
C97 D1_C ELAD1_INV_3/Y 1.39071f
C98 VINM_C CLR_N 0.18324f
C99 ELAD1_INV_4/Y CLR_PC 0.1447f
C100 EN_MG VDPWR 0.80096f
C101 VINM_C SUBI 0.08566f
C102 OUT_B ELAD1_INV_2/Y 0.79342f
C103 REF_C EN_PG 0.89343f
C104 EN_N ELAD1_TSW_0/ELAD1_TGA_1/B 0.62119f
C105 VBIAS_G CLR_PG 0.11961f
C106 EN_N EN_MC 2.80378f
C107 OUT_C EN_PG 0.62051f
C108 EN_N ELAD1_TSW_1/ELAD1_TGA_1/B 0.62518f
C109 D2_C EN_MC 0.03146f
C110 UA0 ELAD1_INV_1/Y 0.82911f
C111 ELAD1_TSW_1/ELAD1_TGA_1/B D2_C 0.0272f
C112 OUT_A VBIAS_C 0.10709f
C113 VINP_C VBIAS_C 0.0488f
C114 D1_C VINM_G 0
C115 VBIAS_G REF_C 3.08041f
C116 OUT_B VDPWR 0.79697f
C117 EN_MG CLR_PG 0.03266f
C118 CLR_N OUT_G 0
C119 ELAD1_INV_3/Y VBIAS_C 0.80574f
C120 UA2 CLR_PC 0.01256f
C121 D1_C VQUIET_A 0
C122 OUT_C VBIAS_G 0
C123 CLR_MG CLR_PC 0
C124 SUBI OUT_G 0.44687f
C125 VQUIET_B CLR_N 0.22447f
C126 UA3 REF_G 2.09977f
C127 EN_MG REF_C 0.57928f
C128 VINP_G CLR_PC 0.06046f
C129 SUBI VQUIET_B 0.12072f
C130 OUT_C EN_MG 0.17187f
C131 EN_PG EN_PC 4.14745f
C132 ELAD1_INV_2/Y ELAD1_TSW_0/ELAD1_TGA_1/B 1.35279f
C133 UA3 ELAD1_INV_4/Y 0.96597f
C134 VINM_G VBIAS_C 0.04607f
C135 EN_MC ELAD1_INV_2/Y 0.16462f
C136 ELAD1_TSW_1/ELAD1_TGA_1/B ELAD1_INV_2/Y 1.35599f
C137 UA1 CLR_PC 0.00735f
C138 VQUIET_A VBIAS_C 0.0412f
C139 VBIAS_G EN_PC 0.59246f
C140 OUT_B OUT_C 0.18126f
C141 VDPWR ELAD1_TSW_0/ELAD1_TGA_1/B 1.32959f
C142 EN_MC VDPWR 0.70872f
C143 ELAD1_TSW_1/ELAD1_TGA_1/B VDPWR 1.43561f
C144 VINM_C OUT_G 0
C145 UA3 UA2 0.00528f
C146 EN_MG EN_PC 0.27846f
C147 EN_N D1_C 0.07277f
C148 D1_C D2_C 3.10008f
C149 UA0 REF_G 4.43749f
C150 CLR_N VINP_C 0.31762f
C151 ELAD1_INV_0/Y EN_PG 0.14148f
C152 VINM_C VQUIET_B 0.08869f
C153 EN_MC CLR_PG 0.025f
C154 CLR_N ELAD1_INV_3/Y 0.09346f
C155 SUBI VINP_C 0.12198f
C156 OUT_B EN_PC 0.09052f
C157 UA0 ELAD1_INV_4/Y 0.96206f
C158 D1_G VINM_C 0
C159 SUBI ELAD1_INV_3/Y 0.14883f
C160 REF_C ELAD1_TSW_0/ELAD1_TGA_1/B 0.00167f
C161 ELAD1_INV_0/Y VBIAS_G 0.19919f
C162 EN_MC REF_C 2.74996f
C163 OUT_C EN_MC 0.47461f
C164 EN_N VBIAS_C 0.18552f
C165 D2_G OUT_G 0.20598f
C166 VQUIET_B OUT_G 0.1301f
C167 VINM_G CLR_N 0.26826f
C168 D1_C ELAD1_INV_2/Y 0.04602f
C169 EN_MG ELAD1_INV_0/Y 1.39749f
C170 CLR_MC EN_PG 0.04571f
C171 D2_G VQUIET_B 0
C172 UA0 UA2 0.04533f
C173 VINM_G SUBI 0.08184f
C174 UA0 CLR_MG 0.08064f
C175 CLR_N VQUIET_A 0.31047f
C176 D1_G VQUIET_B 0
C177 OUT_B ELAD1_INV_0/Y 0.03533f
C178 D1_C VDPWR 0.54661f
C179 SUBI VQUIET_A 0.12373f
C180 VINM_C OUT_A 0
C181 VINM_C VINP_C 0.13672f
C182 UA0 VINP_G 0.06192f
C183 CLR_MC VBIAS_G 0
C184 EN_MC EN_PC 0.29602f
C185 VINM_C ELAD1_INV_3/Y 0.18139f
C186 ELAD1_TSW_1/ELAD1_TGA_1/B EN_PC 0.00169f
C187 UA4 EN_PG 0.2415f
C188 ELAD1_INV_1/Y EN_PG 0.15096f
C189 ELAD1_INV_2/Y VBIAS_C 0.06443f
C190 CLR_MC EN_MG 0.02797f
C191 UA0 UA1 0.07178f
C192 OUT_G VINP_C 0.07648f
C193 ELAD1_INV_1/Y VBIAS_G 0.15212f
C194 D1_C REF_C 0
C195 VDPWR VBIAS_C 1.11766f
C196 VINM_C VINM_G 3.23616f
C197 ELAD1_INV_3/Y OUT_G 0.13344f
C198 OUT_A VQUIET_B 0.00108f
C199 VQUIET_B VINP_C 1.64646f
C200 EN_N CLR_N 0.07847f
C201 OUT_C D1_C 0.04651f
C202 EN_MG UA4 0.23657f
C203 ELAD1_INV_0/Y ELAD1_TSW_0/ELAD1_TGA_1/B 0.00126f
C204 D2_G ELAD1_INV_3/Y 0.03585f
C205 VINM_C VQUIET_A 3.26023f
C206 VQUIET_B ELAD1_INV_3/Y 0.07989f
C207 EN_MG ELAD1_INV_1/Y 0.29353f
C208 ELAD1_INV_0/Y EN_MC 0.21132f
C209 D1_G OUT_A 2.19116f
C210 D1_G VINP_C 0
C211 EN_N SUBI 1.57857f
C212 CLR_PG VBIAS_C 0
C213 D2_C SUBI 0.00746f
C214 D1_G ELAD1_INV_3/Y 0
C215 OUT_B UA4 0.9535f
C216 VINM_G OUT_G 0
C217 OUT_B ELAD1_INV_1/Y 0.04247f
C218 REF_C VBIAS_C 0.33148f
C219 OUT_C VBIAS_C 0
C220 VINM_G VQUIET_B 0.13338f
C221 D1_C EN_PC 0.4443f
C222 OUT_G VQUIET_A 0.08276f
C223 CLR_N ELAD1_INV_2/Y 0.11445f
C224 EN_PG REF_G 0.2314f
C225 D1_G VINM_G 0
C226 CLR_MC EN_MC 0.02959f
C227 VQUIET_B VQUIET_A 3.32555f
C228 SUBI ELAD1_INV_2/Y 0.3474f
C229 OUT_A VINP_C 0
C230 D1_G VQUIET_A 0
C231 VINM_C EN_N 0.09107f
C232 ELAD1_INV_4/Y EN_PG 1.42334f
C233 OUT_A ELAD1_INV_3/Y 0
C234 ELAD1_INV_3/Y VINP_C 0.17278f
C235 VINM_C D2_C 0
C236 VBIAS_G REF_G 0.27713f
C237 CLR_N VDPWR 0.24871f
C238 UA0 CLR_PC 0.05465f
C239 EN_PC VBIAS_C 0.36979f
C240 UA4 EN_MC 0.31718f
C241 SUBI VDPWR 0.96155f
C242 ELAD1_INV_1/Y ELAD1_TSW_0/ELAD1_TGA_1/B 0
C243 ELAD1_TSW_1/ELAD1_TGA_1/B UA4 2.85337f
C244 EN_MC ELAD1_INV_1/Y 1.18696f
C245 D1_C ELAD1_INV_0/Y 0.02787f
C246 ELAD1_INV_4/Y VBIAS_G 0.64738f
C247 EN_MG REF_G 0.57044f
C248 CLR_N CLR_PG 1.4926f
C249 VINM_G OUT_A 0
C250 VINM_G VINP_C 0.23726f
C251 EN_N OUT_G 2.10553f
C252 EN_PG UA2 0.12507f
C253 CLR_MG EN_PG 0.04445f
C254 D2_C OUT_G 0.0398f
C255 SUBI CLR_PG 0
C256 EN_MG ELAD1_INV_4/Y 0.12561f
C257 VINM_G ELAD1_INV_3/Y 0.10896f
C258 EN_N D2_G 0.19265f
C259 REF_C CLR_N 0.11783f
C260 OUT_A VQUIET_A 0
C261 VINP_C VQUIET_A 0.1767f
C262 D2_G D2_C 0.01041f
C263 EN_N VQUIET_B 0.31414f
C264 VINM_C ELAD1_INV_2/Y 0.18815f
C265 D2_C VQUIET_B 0
C266 VINP_G EN_PG 0.17801f
C267 OUT_C CLR_N 0
C268 ELAD1_INV_3/Y VQUIET_A 0.06326f
C269 VBIAS_G UA2 0
C270 SUBI REF_C 0
C271 D1_G EN_N 0.18601f
C272 CLR_MG VBIAS_G 0
C273 ELAD1_INV_0/Y VBIAS_C 0.29694f
C274 OUT_B ELAD1_INV_4/Y 0.0522f
C275 OUT_C SUBI 0.18945f
C276 VINM_C VDPWR 0.3907f
C277 UA0 UA3 1.47956f
C278 EN_MG UA2 0.09829f
C279 VBIAS_G VINP_G 0.04206f
C280 UA1 EN_PG 0.16265f
C281 EN_MG CLR_MG 0.02318f
C282 OUT_G ELAD1_INV_2/Y 0.24675f
C283 VINM_G VQUIET_A 0.11467f
C284 D2_G ELAD1_INV_2/Y 0.35173f
C285 EN_MG VINP_G 0.03142f
C286 CLR_N EN_PC 0.96538f
C287 VINM_C CLR_PG 0.00264f
C288 VQUIET_B ELAD1_INV_2/Y 0.17558f
C289 OUT_B UA2 0
C290 UA1 VBIAS_G 0
C291 D1_C UA4 0.00187f
C292 REF_G ELAD1_TSW_0/ELAD1_TGA_1/B 0.0165f
C293 EN_MC REF_G 0.23966f
C294 D1_C ELAD1_INV_1/Y 0.03185f
C295 SUBI EN_PC 0.05006f
C296 OUT_G VDPWR 0.91049f
C297 D1_G ELAD1_INV_2/Y 0
C298 EN_N VINP_C 0.13075f
C299 EN_N OUT_A 0.63167f
C300 CLR_MC VBIAS_C 0
C301 VINM_C REF_C 0.07663f
C302 D2_C VINP_C 0
C303 D2_G VDPWR 0.52579f
C304 EN_N ELAD1_INV_3/Y 0.28067f
C305 ELAD1_INV_4/Y ELAD1_TSW_0/ELAD1_TGA_1/B 0
C306 UA1 EN_MG 0.02393f
C307 VQUIET_B VDPWR 0.73537f
C308 OUT_C VINM_C 0
C309 ELAD1_INV_4/Y EN_MC 0.31067f
C310 D2_C ELAD1_INV_3/Y 0.65431f
C311 ELAD1_TSW_1/ELAD1_TGA_1/B ELAD1_INV_4/Y 0
C312 D1_G VDPWR 0.5002f
C313 OUT_G CLR_PG 0.00297f
C314 ELAD1_INV_1/Y VBIAS_C 0.58722f
C315 VQUIET_B CLR_PG 0.14414f
C316 ELAD1_INV_0/Y CLR_N 0.21807f
C317 REF_C OUT_G 0
C318 EN_N VINM_G 0.08916f
C319 VINM_G D2_C 0
C320 ELAD1_INV_0/Y SUBI 0.10043f
C321 OUT_C OUT_G 1.92993f
C322 EN_MC UA2 0.09999f
C323 ELAD1_INV_2/Y VINP_C 0.1568f
C324 OUT_A ELAD1_INV_2/Y 0.53528f
C325 CLR_MG EN_MC 0.02489f
C326 REF_C VQUIET_B 0.17668f
C327 EN_N VQUIET_A 0.3011f
C328 VINM_C EN_PC 0.47374f
C329 OUT_C D2_G 0.20792f
C330 ELAD1_INV_3/Y ELAD1_INV_2/Y 4.14578f
C331 D2_C VQUIET_A 0
C332 OUT_C VQUIET_B 0.06569f
C333 D1_G REF_C 0.11169f
C334 EN_MC VINP_G 0.03414f
C335 EN_PG CLR_PC 0.18297f
C336 OUT_A VDPWR 0.57924f
C337 VDPWR VINP_C 0.57298f
C338 D1_C REF_G 0
C339 ELAD1_INV_3/Y VDPWR 4.53877f
C340 CLR_MC CLR_N 0.00345f
C341 EN_PC OUT_G 0.68395f
C342 VINM_G ELAD1_INV_2/Y 0.07641f
C343 VBIAS_G CLR_PC 0.00103f
C344 UA1 EN_MC 0.02577f
C345 CLR_MC SUBI 0
C346 D1_C ELAD1_INV_4/Y 0.03115f
C347 CLR_PG VINP_C 0.07205f
C348 D2_G EN_PC 0.00133f
C349 VQUIET_B EN_PC 0.26413f
C350 VINM_C ELAD1_INV_0/Y 0.10939f
C351 ELAD1_INV_2/Y VQUIET_A 0.20508f
C352 ELAD1_INV_3/Y CLR_PG 0.02813f
C353 EN_MG CLR_PC 0.16937f
C354 D1_G EN_PC 0.04567f
C355 VINM_G VDPWR 0.39026f
C356 OUT_A REF_C 0.11901f
C357 REF_C VINP_C 0.14567f
C358 ELAD1_INV_1/Y CLR_N 0.19747f
C359 REF_G VBIAS_C 0.21392f
C360 EN_N D2_C 0.21851f
C361 REF_C ELAD1_INV_3/Y 0.12976f
C362 OUT_C VINP_C 0.06291f
C363 VDPWR VQUIET_A 0.39717f
C364 ELAD1_INV_1/Y SUBI 0.08814f
C365 OUT_C ELAD1_INV_3/Y 0.13769f
C366 D1_C UA2 0.00573f
C367 UA3 EN_PG 0.37826f
C368 ELAD1_INV_4/Y VBIAS_C 0.47129f
C369 VINM_G CLR_PG 0.09124f
C370 ELAD1_INV_0/Y OUT_G 0.7412f
C371 D2_G ELAD1_INV_0/Y 0.02747f
C372 D1_C VINP_G 0
C373 VINM_C CLR_MC 0
C374 CLR_PG VQUIET_A 0.09903f
C375 ELAD1_INV_0/Y VQUIET_B 0.21586f
C376 UA3 VBIAS_G 0.215f
C377 VINM_G REF_C 0.08258f
C378 D1_G ELAD1_INV_0/Y 0.06655f
C379 OUT_C VINM_G 0.00552f
C380 OUT_A EN_PC 0.06215f
C381 EN_PC VINP_C 0.82239f
C382 EN_N ELAD1_INV_2/Y 1.11338f
C383 REF_C VQUIET_A 0.07972f
C384 D2_C ELAD1_INV_2/Y 0.17383f
C385 EN_MG UA3 0.17587f
C386 ELAD1_INV_3/Y EN_PC 3.96223f
C387 UA2 VBIAS_C 0.00252f
C388 UA1 D1_C 0.001f
C389 CLR_MG VBIAS_C 0
C390 OUT_C VQUIET_A 0.06345f
C391 VINM_C ELAD1_INV_1/Y 0.10076f
C392 CLR_MC OUT_G 0
C393 EN_N VDPWR 1.08233f
C394 UA0 EN_PG 0.68125f
C395 VINP_G VBIAS_C 0
C396 EN_MC CLR_PC 0.10837f
C397 D2_C VDPWR 3.26406f
C398 OUT_B UA3 0
C399 CLR_MC VQUIET_B 0
C400 CLR_N REF_G 0.22351f
C401 VINM_G EN_PC 0.24186f
C402 SUBI REF_G 0.06775f
C403 UA0 VBIAS_G 2.9545f
C404 ELAD1_INV_0/Y OUT_A 0.1004f
C405 ELAD1_INV_0/Y VINP_C 0.13493f
C406 EN_N CLR_PG 0.03702f
C407 UA4 OUT_G 2.66508f
C408 EN_PC VQUIET_A 0.34346f
C409 ELAD1_INV_4/Y CLR_N 0.08976f
C410 ELAD1_INV_1/Y OUT_G 0.13442f
C411 ELAD1_INV_0/Y ELAD1_INV_3/Y 0.20224f
C412 D2_G UA4 3.70233f
C413 ELAD1_INV_4/Y SUBI 0.18495f
C414 D2_G ELAD1_INV_1/Y 0.04417f
C415 UA0 EN_MG 0.36944f
C416 EN_N REF_C 0.18513f
C417 ELAD1_INV_1/Y VQUIET_B 0.16072f
C418 D2_C REF_C 0
C419 ELAD1_INV_2/Y VDPWR 6.97299f
C420 OUT_C EN_N 0.82959f
C421 OUT_C D2_C 0.0562f
C422 D1_G ELAD1_INV_1/Y 0
C423 UA3 ELAD1_TSW_0/ELAD1_TGA_1/B 3.37104f
C424 UA3 EN_MC 0.31895f
C425 ELAD1_INV_0/Y VINM_G 0.21674f
C426 CLR_N UA2 0.00143f
C427 ELAD1_TSW_1/ELAD1_TGA_1/B UA3 0.06124f
C428 CLR_MG CLR_N 0.00305f
C429 CLR_MC VINP_C 0.01232f
C430 ELAD1_INV_2/Y CLR_PG 0.02831f
C431 SUBI UA2 1.55162f
C432 ELAD1_INV_0/Y VQUIET_A 0.12065f
C433 CLR_MC ELAD1_INV_3/Y 0.03428f
C434 CLR_MG SUBI 0.00281f
C435 VINM_C REF_G 0.08226f
C436 VINP_G CLR_N 0.21598f
C437 REF_C ELAD1_INV_2/Y 0.13193f
C438 EN_N EN_PC 2.01062f
C439 VINP_G SUBI 0.0878f
C440 D2_C EN_PC 0.53209f
C441 CLR_PG VDPWR 0.15663f
C442 VINM_C ELAD1_INV_4/Y 0.05872f
C443 OUT_C ELAD1_INV_2/Y 0.27203f
C444 ELAD1_INV_1/Y OUT_A 0.00288f
C445 ELAD1_INV_1/Y VINP_C 0.13075f
C446 UA1 CLR_N 0
C447 UA4 ELAD1_INV_3/Y 0.83124f
C448 CLR_MC VINM_G 0.00131f
C449 ELAD1_INV_1/Y ELAD1_INV_3/Y 0.17225f
C450 REF_C VDPWR 1.07299f
C451 UA1 SUBI 1.37912f
C452 UA0 EN_MC 0.3964f
C453 OUT_C VDPWR 0.96659f
C454 CLR_MC VQUIET_A 0
C455 CLR_PC VBIAS_C 0.11643f
C456 VQUIET_B REF_G 0.09716f
C457 ELAD1_INV_4/Y OUT_G 0.25887f
C458 VINM_C UA2 0.8342f
C459 VINM_C CLR_MG 0
C460 D1_G REF_G 2.35336f
C461 REF_C CLR_PG 0.04723f
C462 EN_PC ELAD1_INV_2/Y 0.22912f
C463 EN_N ELAD1_INV_0/Y 0.33187f
C464 D2_G ELAD1_INV_4/Y 0.54739f
C465 ELAD1_INV_0/Y D2_C 0.03033f
C466 ELAD1_INV_4/Y VQUIET_B 0.07541f
C467 VINM_G ELAD1_INV_1/Y 0.1104f
C468 OUT_C CLR_PG 0.0023f
C469 D1_C UA3 2.79522f
C470 VINM_C VINP_G 0.00477f
C471 D1_G ELAD1_INV_4/Y 0.4753f
C472 ELAD1_INV_1/Y VQUIET_A 0.10086f
C473 EN_PC VDPWR 1.01143f
C474 OUT_C REF_C 0
C475 OUT_G UA2 0.88941f
C476 CLR_MG OUT_G 0
C477 VINM_C UA1 0
C478 VQUIET_B UA2 0.09692f
C479 CLR_MG VQUIET_B 0
C480 VINP_G OUT_G 0.04545f
C481 UA3 VBIAS_C 0.25015f
C482 EN_N CLR_MC 0.04256f
C483 EN_PC CLR_PG 0.17668f
C484 OUT_A REF_G 0.24608f
C485 REF_G VINP_C 0.10066f
C486 ELAD1_INV_0/Y ELAD1_INV_2/Y 0.3844f
C487 VBIAS_G EN_PG 0.65109f
C488 ELAD1_INV_3/Y REF_G 0.11521f
C489 VINP_G VQUIET_B 0.03523f
C490 REF_C EN_PC 0.25414f
C491 UA0 D1_C 0
C492 ELAD1_INV_4/Y OUT_A 0
C493 CLR_N CLR_PC 0.37203f
C494 ELAD1_INV_4/Y VINP_C 0.28865f
C495 EN_MG EN_PG 0.31706f
C496 UA1 OUT_G 0.18464f
C497 ELAD1_INV_0/Y VDPWR 6.52571f
C498 OUT_C EN_PC 0.15691f
C499 ELAD1_INV_4/Y ELAD1_INV_3/Y 4.54272f
C500 EN_N UA4 0.70373f
C501 SUBI CLR_PC 0.00259f
C502 EN_N ELAD1_INV_1/Y 0.13456f
C503 UA4 D2_C 2.6476f
C504 UA1 VQUIET_B 0.873f
C505 D2_C ELAD1_INV_1/Y 0.03318f
C506 VINM_G REF_G 0.08775f
C507 EN_MG VBIAS_G 0.17665f
C508 OUT_B EN_PG 0.02049f
C509 CLR_MC ELAD1_INV_2/Y 0.03429f
C510 ELAD1_INV_0/Y CLR_PG 0.09234f
C511 UA2 VINP_C 0.05968f
C512 REF_G VQUIET_A 0.18891f
C513 CLR_MG VINP_C 0
C514 UA0 VBIAS_C 2.73724f
C515 ELAD1_INV_4/Y VINM_G 0.22884f
C516 ELAD1_INV_3/Y UA2 0.40498f
C517 CLR_MG ELAD1_INV_3/Y 0.02819f
C518 ELAD1_INV_0/Y REF_C 0.15801f
C519 CLR_MC VDPWR 0.19074f
C520 ELAD1_INV_4/Y VQUIET_A 0.05878f
C521 VINP_G VINP_C 0.15765f
C522 OUT_C ELAD1_INV_0/Y 0.07274f
C523 UA4 ELAD1_INV_2/Y 1.81144f
C524 VINP_G ELAD1_INV_3/Y 0.08569f
C525 UA3 CLR_N 0.0952f
C526 ELAD1_INV_1/Y ELAD1_INV_2/Y 0.37919f
C527 OUT_B EN_MG 0.01253f
C528 VINM_C CLR_PC 0.17097f
C529 UA3 SUBI 0.03511f
C530 VINM_G UA2 0.84226f
C531 CLR_MC CLR_PG 0.15783f
C532 UA1 VINP_C 0.92242f
C533 EN_PG ELAD1_TSW_0/ELAD1_TGA_1/B 0
C534 CLR_MG VINM_G 0.00131f
C535 EN_MC EN_PG 0.33473f
C536 UA4 VDPWR 5.08766f
C537 ELAD1_TSW_1/ELAD1_TGA_1/B EN_PG 0.00126f
C538 UA1 ELAD1_INV_3/Y 0.33242f
C539 ELAD1_INV_1/Y VDPWR 3.74976f
C540 UA2 VQUIET_A 0.06318f
C541 CLR_MG VQUIET_A 0
C542 VINM_G VINP_G 1.55194f
C543 CLR_MC REF_C 0.07125f
C544 ELAD1_INV_0/Y EN_PC 0.22761f
C545 EN_N REF_G 0.18306f
C546 D2_C REF_G 0
C547 VBIAS_G ELAD1_TSW_0/ELAD1_TGA_1/B 0
C548 OUT_C CLR_MC 0.00146f
C549 OUT_G CLR_PC 0.00456f
C550 EN_MC VBIAS_G 0.19255f
C551 VINP_G VQUIET_A 0.06769f
C552 ELAD1_INV_1/Y CLR_PG 0.02825f
C553 VQUIET_B CLR_PC 0.06342f
C554 EN_N ELAD1_INV_4/Y 0.18643f
C555 UA1 VINM_G 0
C556 EN_MG ELAD1_TSW_0/ELAD1_TGA_1/B 0
C557 ELAD1_INV_4/Y D2_C 0.03352f
C558 UA0 CLR_N 0.04429f
C559 EN_MG EN_MC 4.55311f
C560 ELAD1_INV_1/Y REF_C 1.25736f
C561 VINM_C UA3 0.04501f
C562 OUT_C UA4 2.74243f
C563 UA1 VQUIET_A 0.91677f
C564 UA0 SUBI 0.83163f
C565 OUT_C ELAD1_INV_1/Y 0.77145f
C566 CLR_MC EN_PC 0.04139f
C567 OUT_B EN_MC 0.23856f
C568 REF_G ELAD1_INV_2/Y 0.4185f
C569 OUT_B ELAD1_TSW_1/ELAD1_TGA_1/B 2.99855f
C570 EN_N UA2 0.32186f
C571 EN_N CLR_MG 0.03783f
C572 D2_C UA2 0.03164f
C573 ELAD1_INV_4/Y ELAD1_INV_2/Y 1.02818f
C574 D1_C EN_PG 2.51209f
C575 EN_N VINP_G 0.09421f
C576 REF_G VDPWR 1.51825f
C577 D2_C VINP_G 0
C578 UA4 EN_PC 0.24359f
C579 UA3 VQUIET_B 0.05578f
C580 ELAD1_INV_1/Y EN_PC 0.16062f
C581 CLR_PC VINP_C 0.15849f
C582 ELAD1_INV_3/Y CLR_PC 0.09717f
C583 UA0 VINM_C 0.04676f
C584 ELAD1_INV_4/Y VDPWR 5.02491f
C585 D1_G UA3 2.81316f
C586 UA1 EN_N 0.33577f
C587 CLR_MC ELAD1_INV_0/Y 0.02876f
C588 REF_G CLR_PG 0.04794f
C589 UA1 D2_C 0.00192f
C590 UA2 ELAD1_INV_2/Y 0.77183f
C591 EN_MC ELAD1_TSW_0/ELAD1_TGA_1/B 0
C592 CLR_MG ELAD1_INV_2/Y 0.02828f
C593 EN_PG VBIAS_C 1.24898f
C594 D1_C EN_MG 0.02969f
C595 ELAD1_INV_4/Y CLR_PG 0.02858f
C596 REF_C REF_G 0.3412f
C597 VINP_G ELAD1_INV_2/Y 0.09419f
C598 VINM_G CLR_PC 0.11651f
C599 UA0 OUT_G 0.04525f
C600 ELAD1_INV_0/Y UA4 0.55932f
C601 UA2 VDPWR 2.15f
C602 CLR_MG VDPWR 0.15337f
C603 ELAD1_INV_0/Y ELAD1_INV_1/Y 5.22252f
C604 VBIAS_G VBIAS_C 0.13122f
C605 ELAD1_INV_4/Y REF_C 0.12211f
C606 OUT_B D1_C 0.06148f
C607 CLR_PC VQUIET_A 0.06165f
C608 UA0 VQUIET_B 0.05761f
C609 OUT_C ELAD1_INV_4/Y 0.23367f
C610 UA3 VINP_C 0.05468f
C611 UA3 OUT_A 0.69159f
C612 VINP_G VDPWR 0.45104f
C613 UA1 ELAD1_INV_2/Y 0.43028f
C614 D1_G UA0 0.58754f
C615 EN_MG VBIAS_C 0.09254f
C616 UA2 CLR_PG 0.00317f
C617 UA3 ELAD1_INV_3/Y 0.94138f
C618 CLR_MG CLR_PG 0.78622f
C619 EN_PC REF_G 0.32958f
C620 REF_C UA2 0
C621 UA1 VDPWR 1.3721f
C622 VINP_G CLR_PG 0.17589f
C623 CLR_MG REF_C 0.00242f
C624 OUT_C UA2 0.9355f
C625 CLR_MC ELAD1_INV_1/Y 0.03467f
C626 OUT_C CLR_MG 0.00104f
C627 ELAD1_INV_4/Y EN_PC 0.19221f
C628 UA3 VINM_G 0.05116f
C629 VINP_G REF_C 0.12976f
C630 CLR_N EN_PG 0.09419f
C631 D1_C EN_MC 0.03235f
C632 UA1 CLR_PG 0.0012f
C633 OUT_C VINP_G 0.04889f
C634 ELAD1_TSW_1/ELAD1_TGA_1/B D1_C 0.02829f
C635 EN_N CLR_PC 0.14683f
C636 UA3 VQUIET_A 0.04582f
C637 UA0 OUT_A 0.45463f
C638 UA0 VINP_C 0.05569f
C639 SUBI EN_PG 0.35165f
C640 UA4 ELAD1_INV_1/Y 0.72385f
C641 UA0 ELAD1_INV_3/Y 0.8717f
C642 UA1 REF_C 0
C643 VBIAS_G CLR_N 0.04887f
C644 ELAD1_INV_0/Y REF_G 1.42918f
C645 EN_PC UA2 0.23602f
C646 OUT_C UA1 0.10238f
C647 CLR_MG EN_PC 0.03555f
C648 VBIAS_G SUBI 0
C649 EN_MC VBIAS_C 0.76599f
C650 EN_MG CLR_N 0.1638f
C651 ELAD1_INV_0/Y ELAD1_INV_4/Y 0.22453f
C652 VINP_G EN_PC 0.20392f
C653 UA0 VINM_G 0.04673f
C654 EN_MG SUBI 0.037f
C655 ELAD1_INV_2/Y CLR_PC 0.08801f
C656 UA0 VQUIET_A 0.04677f
C657 VINM_C EN_PG 0.08312f
C658 UA1 EN_PC 0.09703f
C659 EN_N UA3 0.40005f
C660 CLR_MC REF_G 0
C661 UA3 D2_C 0.06384f
C662 ELAD1_INV_0/Y UA2 0.36364f
C663 CLR_PC VDPWR 0.19337f
C664 ELAD1_INV_0/Y CLR_MG 0.02389f
C665 CLR_MC ELAD1_INV_4/Y 0.03774f
C666 VINM_C VBIAS_G 0.04327f
C667 ELAD1_INV_0/Y VINP_G 0.03283f
C668 CLR_PG CLR_PC 0.27f
C669 EN_PG OUT_G 0.16668f
C670 ELAD1_INV_1/Y REF_G 0.15457f
C671 VINM_C EN_MG 0.09309f
C672 D2_G EN_PG 0.25367f
C673 VQUIET_B EN_PG 0.09711f
C674 ELAD1_INV_4/Y UA4 1.3634f
C675 UA3 ELAD1_INV_2/Y 1.1015f
C676 REF_C CLR_PC 0
C677 UA1 ELAD1_INV_0/Y 0.02754f
C678 ELAD1_INV_4/Y ELAD1_INV_1/Y 5.24433f
C679 CLR_MC UA2 0
C680 EN_MC CLR_N 0.10095f
C681 VBIAS_G OUT_G 0
C682 UA0 EN_N 0.44341f
C683 CLR_MC CLR_MG 0.78647f
C684 OUT_C CLR_PC 1.889f
C685 D1_G EN_PG 0.27546f
C686 UA0 D2_C 0
C687 EN_MC SUBI 0.03831f
C688 ELAD1_TSW_1/ELAD1_TGA_1/B SUBI 0
C689 VBIAS_G VQUIET_B 0.0735f
C690 UA3 VDPWR 5.04947f
C691 CLR_MC VINP_G 0.09931f
C692 EN_MG OUT_G 0.49068f
C693 D1_G VBIAS_G 0.11138f
C694 D2_G EN_MG 0.00204f
C695 UA4 UA2 0.00107f
C696 EN_MG VQUIET_B 0.31385f
C697 ELAD1_INV_1/Y UA2 0.32708f
C698 CLR_MG ELAD1_INV_1/Y 0.02806f
C699 UA1 CLR_MC 0.00253f
C700 OUT_B OUT_G 0.1898f
C701 D1_G EN_MG 0.1407f
C702 EN_PC CLR_PC 0.15343f
C703 CLR_PC VGND 3.39855f **FLOATING
C704 VQUIET_B VGND 1.88173f **FLOATING
C705 VQUIET_A VGND 1.62507f **FLOATING
C706 VINP_C VGND 1.8249f **FLOATING
C707 VINP_G VGND 2.23675f **FLOATING
C708 ELAD1_INV_1/Y VGND 2.77851f **FLOATING
C709 EN_MC VGND 5.62178f
C710 ELAD1_INV_0/Y VGND 3.83307f **FLOATING
C711 EN_MG VGND 5.77804f
C712 VDPWR VGND 0.10011p **FLOATING
C713 D2_G VGND 0.86175f **FLOATING
C714 VBIAS_G VGND 1.78594f **FLOATING
C715 EN_PG VGND 6.4562f
C716 ELAD1_INV_4/Y VGND 2.9061f **FLOATING
C717 D1_C VGND 1.23555f **FLOATING
C718 UA1 VGND 1.03497f **FLOATING
C719 D2_C VGND 1.65937f **FLOATING
C720 OUT_C VGND 2.17475f **FLOATING
C721 ELAD1_TSW_1/ELAD1_TGA_1/B VGND 1.80184f **FLOATING
C722 OUT_B VGND 1.39734f **FLOATING
C723 UA4 VGND 3.47573f **FLOATING
C724 OUT_G VGND 1.75976f **FLOATING
C725 ELAD1_TSW_0/ELAD1_TGA_1/B VGND 1.80075f **FLOATING
C726 EN_N VGND 9.37339f
C727 ELAD1_INV_2/Y VGND 4.3532f **FLOATING
C728 OUT_A VGND 1.94102f **FLOATING
C729 REF_C VGND 2.68836f **FLOATING
C730 VINM_G VGND 2.08791f **FLOATING
C731 UA0 VGND 3.45423f **FLOATING
C732 REF_G VGND 2.25661f **FLOATING
C733 VBIAS_C VGND 1.15658f **FLOATING
C734 EN_PC VGND 8.35811f
C735 ELAD1_INV_3/Y VGND 5.30484f **FLOATING
C736 UA3 VGND 5.12879f **FLOATING
C737 D1_G VGND 0.97159f **FLOATING
C738 CLR_MG VGND 0.90678f **FLOATING
C739 CLR_MC VGND 1.18642f **FLOATING
C740 CLR_PG VGND 2.5268f **FLOATING
C741 CLR_N VGND 2.64463f **FLOATING
C742 SUBI VGND 1.12119f **FLOATING
C743 UA2 VGND 1.39709f **FLOATING
C744 VINM_C VGND 1.10315f **FLOATING
