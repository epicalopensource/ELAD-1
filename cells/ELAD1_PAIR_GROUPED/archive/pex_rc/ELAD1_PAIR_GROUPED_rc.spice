* SPICE3 file created from ELAD1_PAIR_GROUPED_flat.ext - technology: sky130A

X0 D1.t5 VINP.t1 a_433_1469.t22 VGND.t1 sky130_fd_pr__nfet_01v8 ad=0.25 pd=1.5 as=0.25 ps=1.5 w=1 l=1
X1 VGND.t23 VBIAS.t20 a_433_1469.t3 VGND.t2 sky130_fd_pr__nfet_01v8 ad=0.25 pd=1.5 as=0.25 ps=1.5 w=1 l=1
X2 a_433_1469.t38 a_433_1469.t36 a_433_1469.t37 VGND.t8 sky130_fd_pr__nfet_01v8 ad=0.25 pd=1.5 as=0 ps=0 w=1 l=1
X3 D1.t1 VINP.t7 a_433_1469.t16 VGND.t6 sky130_fd_pr__nfet_01v8 ad=0.25 pd=1.5 as=0.25 ps=1.5 w=1 l=1
X4 D2.t1 VINM.t3 a_433_1469.t12 VGND.t5 sky130_fd_pr__nfet_01v8 ad=0.25 pd=1.5 as=0.25 ps=1.5 w=1 l=1
X5 VGND.t30 VGND.t28 VGND.t29 VGND.t11 sky130_fd_pr__nfet_01v8 ad=0.5 pd=3 as=0 ps=0 w=1 l=1
X6 VGND.t22 VBIAS.t22 a_433_1469.t1 VGND.t7 sky130_fd_pr__nfet_01v8 ad=0.25 pd=1.5 as=0.25 ps=1.5 w=1 l=1
X7 a_433_1469.t53 a_433_1469.t51 a_433_1469.t52 VGND.t0 sky130_fd_pr__nfet_01v8 ad=0.25 pd=1.5 as=0 ps=0 w=1 l=1
X8 a_433_1469.t116 a_433_1469.t114 a_433_1469.t115 VGND.t9 sky130_fd_pr__nfet_01v8 ad=0.25 pd=1.5 as=0 ps=0 w=1 l=1
X9 a_433_1469.t74 a_433_1469.t72 a_433_1469.t73 VGND.t11 sky130_fd_pr__nfet_01v8 ad=0.5 pd=3 as=0 ps=0 w=1 l=1
X10 a_433_1469.t4 VBIAS.t19 VGND.t25 VGND.t5 sky130_fd_pr__nfet_01v8 ad=0.25 pd=1.5 as=0.25 ps=1.5 w=1 l=1
X11 VGND.t33 VGND.t31 VGND.t32 VGND.t10 sky130_fd_pr__nfet_01v8 ad=0.25 pd=1.5 as=0 ps=0 w=1 l=1
X12 a_433_1469.t2 VBIAS.t21 VGND.t24 VGND.t8 sky130_fd_pr__nfet_01v8 ad=0.25 pd=1.5 as=0.25 ps=1.5 w=1 l=1
X13 a_433_1469.t71 a_433_1469.t69 a_433_1469.t70 VGND.t3 sky130_fd_pr__nfet_01v8 ad=0.25 pd=1.5 as=0 ps=0 w=1 l=1
X14 D2.t5 VINM.t5 a_433_1469.t10 VGND.t8 sky130_fd_pr__nfet_01v8 ad=0.25 pd=1.5 as=0.25 ps=1.5 w=1 l=1
X15 VGND.t27 VBIAS.t16 a_433_1469.t7 VGND.t0 sky130_fd_pr__nfet_01v8 ad=0.25 pd=1.5 as=0.25 ps=1.5 w=1 l=1
X16 a_433_1469.t47 a_433_1469.t45 a_433_1469.t46 VGND.t4 sky130_fd_pr__nfet_01v8 ad=0.25 pd=1.5 as=0 ps=0 w=1 l=1
X17 a_433_1469.t19 VINP.t4 D1.t2 VGND.t2 sky130_fd_pr__nfet_01v8 ad=0.25 pd=1.5 as=0.25 ps=1.5 w=1 l=1
X18 a_433_1469.t15 VINM.t0 D2.t7 VGND.t0 sky130_fd_pr__nfet_01v8 ad=0.25 pd=1.5 as=0.25 ps=1.5 w=1 l=1
X19 a_433_1469.t110 a_433_1469.t108 a_433_1469.t109 VGND.t1 sky130_fd_pr__nfet_01v8 ad=0.25 pd=1.5 as=0 ps=0 w=1 l=1
X20 VGND.t12 VBIAS.t18 a_433_1469.t5 VGND.t4 sky130_fd_pr__nfet_01v8 ad=0.25 pd=1.5 as=0.25 ps=1.5 w=1 l=1
X21 a_433_1469.t92 a_433_1469.t90 a_433_1469.t91 VGND.t6 sky130_fd_pr__nfet_01v8 ad=0.25 pd=1.5 as=0 ps=0 w=1 l=1
X22 a_433_1469.t29 a_433_1469.t27 a_433_1469.t28 VGND.t10 sky130_fd_pr__nfet_01v8 ad=0.25 pd=1.5 as=0 ps=0 w=1 l=1
X23 VGND.t48 VGND.t46 VGND.t47 VGND.t9 sky130_fd_pr__nfet_01v8 ad=0.25 pd=1.5 as=0 ps=0 w=1 l=1
X24 a_433_1469.t6 VBIAS.t17 VGND.t26 VGND.t1 sky130_fd_pr__nfet_01v8 ad=0.25 pd=1.5 as=0.25 ps=1.5 w=1 l=1
X25 a_433_1469.t56 a_433_1469.t54 a_433_1469.t55 VGND.t9 sky130_fd_pr__nfet_01v8 ad=0.25 pd=1.5 as=0 ps=0 w=1 l=1
X26 a_433_1469.t17 VINP.t6 D1.t4 VGND.t7 sky130_fd_pr__nfet_01v8 ad=0.25 pd=1.5 as=0.25 ps=1.5 w=1 l=1
X27 a_433_1469.t13 VINM.t2 D2.t3 VGND.t4 sky130_fd_pr__nfet_01v8 ad=0.25 pd=1.5 as=0.25 ps=1.5 w=1 l=1
X28 VBIAS.t11 VBIAS.t10 VGND.t14 VGND.t6 sky130_fd_pr__nfet_01v8 ad=0.25 pd=1.5 as=0.25 ps=1.5 w=1 l=1
X29 a_433_1469.t119 a_433_1469.t117 a_433_1469.t118 VGND.t3 sky130_fd_pr__nfet_01v8 ad=0.25 pd=1.5 as=0 ps=0 w=1 l=1
X30 VGND.t51 VGND.t49 VGND.t50 VGND.t3 sky130_fd_pr__nfet_01v8 ad=0.25 pd=1.5 as=0 ps=0 w=1 l=1
X31 a_433_1469.t77 a_433_1469.t75 a_433_1469.t76 VGND.t10 sky130_fd_pr__nfet_01v8 ad=0.25 pd=1.5 as=0 ps=0 w=1 l=1
X32 a_433_1469.t101 a_433_1469.t99 a_433_1469.t100 VGND.t2 sky130_fd_pr__nfet_01v8 ad=0.25 pd=1.5 as=0 ps=0 w=1 l=1
X33 VGND.t17 VBIAS.t2 VBIAS.t3 VGND.t2 sky130_fd_pr__nfet_01v8 ad=0.25 pd=1.5 as=0.25 ps=1.5 w=1 l=1
X34 a_433_1469.t50 a_433_1469.t48 a_433_1469.t49 VGND.t1 sky130_fd_pr__nfet_01v8 ad=0.25 pd=1.5 as=0 ps=0 w=1 l=1
X35 VGND.t15 VBIAS.t8 VBIAS.t9 VGND.t7 sky130_fd_pr__nfet_01v8 ad=0.25 pd=1.5 as=0.25 ps=1.5 w=1 l=1
X36 a_433_1469.t32 a_433_1469.t30 a_433_1469.t31 VGND.t6 sky130_fd_pr__nfet_01v8 ad=0.25 pd=1.5 as=0 ps=0 w=1 l=1
X37 D1.t3 VINP.t3 a_433_1469.t20 VGND.t5 sky130_fd_pr__nfet_01v8 ad=0.25 pd=1.5 as=0.25 ps=1.5 w=1 l=1
X38 a_433_1469.t80 a_433_1469.t78 a_433_1469.t79 VGND.t9 sky130_fd_pr__nfet_01v8 ad=0.25 pd=1.5 as=0 ps=0 w=1 l=1
X39 a_433_1469.t95 a_433_1469.t93 a_433_1469.t94 VGND.t7 sky130_fd_pr__nfet_01v8 ad=0.25 pd=1.5 as=0 ps=0 w=1 l=1
X40 VBIAS.t1 VBIAS.t0 VGND.t18 VGND.t5 sky130_fd_pr__nfet_01v8 ad=0.25 pd=1.5 as=0.25 ps=1.5 w=1 l=1
X41 a_433_1469.t62 a_433_1469.t60 a_433_1469.t61 VGND.t11 sky130_fd_pr__nfet_01v8 ad=0.5 pd=3 as=0 ps=0 w=1 l=1
X42 VBIAS.t7 VBIAS.t6 VGND.t16 VGND.t8 sky130_fd_pr__nfet_01v8 ad=0.25 pd=1.5 as=0.25 ps=1.5 w=1 l=1
X43 VGND.t21 VBIAS.t4 VBIAS.t5 VGND.t0 sky130_fd_pr__nfet_01v8 ad=0.25 pd=1.5 as=0.25 ps=1.5 w=1 l=1
X44 D2.t2 VINM.t1 a_433_1469.t14 VGND.t1 sky130_fd_pr__nfet_01v8 ad=0.25 pd=1.5 as=0.25 ps=1.5 w=1 l=1
X45 a_433_1469.t59 a_433_1469.t57 a_433_1469.t58 VGND.t3 sky130_fd_pr__nfet_01v8 ad=0.25 pd=1.5 as=0 ps=0 w=1 l=1
X46 D1.t0 VINP.t5 a_433_1469.t18 VGND.t8 sky130_fd_pr__nfet_01v8 ad=0.25 pd=1.5 as=0.25 ps=1.5 w=1 l=1
X47 D2.t4 VINM.t7 a_433_1469.t8 VGND.t6 sky130_fd_pr__nfet_01v8 ad=0.25 pd=1.5 as=0.25 ps=1.5 w=1 l=1
X48 VGND.t19 VBIAS.t14 VBIAS.t15 VGND.t4 sky130_fd_pr__nfet_01v8 ad=0.25 pd=1.5 as=0.25 ps=1.5 w=1 l=1
X49 a_433_1469.t41 a_433_1469.t39 a_433_1469.t40 VGND.t2 sky130_fd_pr__nfet_01v8 ad=0.25 pd=1.5 as=0 ps=0 w=1 l=1
X50 a_433_1469.t23 VINP.t0 D1.t6 VGND.t0 sky130_fd_pr__nfet_01v8 ad=0.25 pd=1.5 as=0.25 ps=1.5 w=1 l=1
X51 a_433_1469.t104 a_433_1469.t102 a_433_1469.t103 VGND.t5 sky130_fd_pr__nfet_01v8 ad=0.25 pd=1.5 as=0 ps=0 w=1 l=1
X52 VGND.t36 VGND.t34 VGND.t35 VGND.t9 sky130_fd_pr__nfet_01v8 ad=0.25 pd=1.5 as=0 ps=0 w=1 l=1
X53 VGND.t42 VGND.t40 VGND.t41 VGND.t11 sky130_fd_pr__nfet_01v8 ad=0.5 pd=3 as=0 ps=0 w=1 l=1
X54 a_433_1469.t86 a_433_1469.t84 a_433_1469.t85 VGND.t11 sky130_fd_pr__nfet_01v8 ad=0.5 pd=3 as=0 ps=0 w=1 l=1
X55 VBIAS.t13 VBIAS.t12 VGND.t20 VGND.t1 sky130_fd_pr__nfet_01v8 ad=0.25 pd=1.5 as=0.25 ps=1.5 w=1 l=1
X56 a_433_1469.t83 a_433_1469.t81 a_433_1469.t82 VGND.t3 sky130_fd_pr__nfet_01v8 ad=0.25 pd=1.5 as=0 ps=0 w=1 l=1
X57 a_433_1469.t35 a_433_1469.t33 a_433_1469.t34 VGND.t7 sky130_fd_pr__nfet_01v8 ad=0.25 pd=1.5 as=0 ps=0 w=1 l=1
X58 a_433_1469.t21 VINP.t2 D1.t7 VGND.t4 sky130_fd_pr__nfet_01v8 ad=0.25 pd=1.5 as=0.25 ps=1.5 w=1 l=1
X59 a_433_1469.t11 VINM.t4 D2.t6 VGND.t2 sky130_fd_pr__nfet_01v8 ad=0.25 pd=1.5 as=0.25 ps=1.5 w=1 l=1
X60 a_433_1469.t98 a_433_1469.t96 a_433_1469.t97 VGND.t8 sky130_fd_pr__nfet_01v8 ad=0.25 pd=1.5 as=0 ps=0 w=1 l=1
X61 VGND.t39 VGND.t37 VGND.t38 VGND.t3 sky130_fd_pr__nfet_01v8 ad=0.25 pd=1.5 as=0 ps=0 w=1 l=1
X62 VGND.t45 VGND.t43 VGND.t44 VGND.t10 sky130_fd_pr__nfet_01v8 ad=0.25 pd=1.5 as=0 ps=0 w=1 l=1
X63 a_433_1469.t113 a_433_1469.t111 a_433_1469.t112 VGND.t0 sky130_fd_pr__nfet_01v8 ad=0.25 pd=1.5 as=0 ps=0 w=1 l=1
X64 a_433_1469.t65 a_433_1469.t63 a_433_1469.t64 VGND.t10 sky130_fd_pr__nfet_01v8 ad=0.25 pd=1.5 as=0 ps=0 w=1 l=1
X65 a_433_1469.t9 VINM.t6 D2.t0 VGND.t7 sky130_fd_pr__nfet_01v8 ad=0.25 pd=1.5 as=0.25 ps=1.5 w=1 l=1
X66 a_433_1469.t44 a_433_1469.t42 a_433_1469.t43 VGND.t5 sky130_fd_pr__nfet_01v8 ad=0.25 pd=1.5 as=0 ps=0 w=1 l=1
X67 a_433_1469.t68 a_433_1469.t66 a_433_1469.t67 VGND.t9 sky130_fd_pr__nfet_01v8 ad=0.25 pd=1.5 as=0 ps=0 w=1 l=1
X68 a_433_1469.t107 a_433_1469.t105 a_433_1469.t106 VGND.t4 sky130_fd_pr__nfet_01v8 ad=0.25 pd=1.5 as=0 ps=0 w=1 l=1
X69 a_433_1469.t0 VBIAS.t23 VGND.t13 VGND.t6 sky130_fd_pr__nfet_01v8 ad=0.25 pd=1.5 as=0.25 ps=1.5 w=1 l=1
X70 a_433_1469.t26 a_433_1469.t24 a_433_1469.t25 VGND.t11 sky130_fd_pr__nfet_01v8 ad=0.5 pd=3 as=0 ps=0 w=1 l=1
X71 a_433_1469.t89 a_433_1469.t87 a_433_1469.t88 VGND.t10 sky130_fd_pr__nfet_01v8 ad=0.25 pd=1.5 as=0 ps=0 w=1 l=1
C0 VINP VBIAS 0
C1 VINM D1 0.2014f
C2 D1 VBIAS 0.02045f
C3 D2 VINP 0.09318f
C4 D2 D1 0.37021f
C5 VINP D1 1.05439f
C6 VINM VBIAS 0.06029f
C7 VINM D2 0.55166f
C8 D2 VBIAS 0.0491f
C9 VINM VINP 1.40874f
R0 VBIAS.n22 VBIAS.n21 184.74
R1 VBIAS.n27 VBIAS.n26 184.74
R2 VBIAS.n33 VBIAS.n32 184.74
R3 VBIAS.n38 VBIAS.n37 184.74
R4 VBIAS.n44 VBIAS.n43 184.74
R5 VBIAS.n49 VBIAS.n48 184.74
R6 VBIAS.n56 VBIAS.n55 184.74
R7 VBIAS.n76 VBIAS.n75 184.74
R8 VBIAS.n81 VBIAS.n80 184.74
R9 VBIAS.n86 VBIAS.n85 184.74
R10 VBIAS.n91 VBIAS.n90 184.74
R11 VBIAS.n96 VBIAS.n95 184.74
R12 VBIAS.n101 VBIAS.n100 184.74
R13 VBIAS.n106 VBIAS.n105 184.74
R14 VBIAS.n19 VBIAS.n18 97.455
R15 VBIAS.n30 VBIAS.n13 97.455
R16 VBIAS.n41 VBIAS.n8 97.455
R17 VBIAS.n52 VBIAS.n3 97.455
R18 VBIAS.n74 VBIAS.t16 85.142
R19 VBIAS.n19 VBIAS.t4 84.9569
R20 VBIAS.n23 VBIAS.n22 77.1778
R21 VBIAS.n28 VBIAS.n27 77.1778
R22 VBIAS.n34 VBIAS.n33 77.1778
R23 VBIAS.n39 VBIAS.n38 77.1778
R24 VBIAS.n45 VBIAS.n44 77.1778
R25 VBIAS.n50 VBIAS.n49 77.1778
R26 VBIAS.n55 VBIAS.n54 77.1778
R27 VBIAS.n77 VBIAS.n76 77.1778
R28 VBIAS.n82 VBIAS.n81 77.1778
R29 VBIAS.n87 VBIAS.n86 77.1778
R30 VBIAS.n92 VBIAS.n91 77.1778
R31 VBIAS.n97 VBIAS.n96 77.1778
R32 VBIAS.n102 VBIAS.n101 77.1778
R33 VBIAS.n107 VBIAS.n106 77.1778
R34 VBIAS.n18 VBIAS.t13 30.0005
R35 VBIAS.n18 VBIAS.t5 30.0005
R36 VBIAS.n13 VBIAS.t1 30.0005
R37 VBIAS.n13 VBIAS.t15 30.0005
R38 VBIAS.n8 VBIAS.t7 30.0005
R39 VBIAS.n8 VBIAS.t3 30.0005
R40 VBIAS.n3 VBIAS.t11 30.0005
R41 VBIAS.n3 VBIAS.t9 30.0005
R42 VBIAS.n21 VBIAS.n17 27.1064
R43 VBIAS.n26 VBIAS.n15 27.1064
R44 VBIAS.n32 VBIAS.n12 27.1064
R45 VBIAS.n37 VBIAS.n10 27.1064
R46 VBIAS.n43 VBIAS.n7 27.1064
R47 VBIAS.n48 VBIAS.n5 27.1064
R48 VBIAS.n56 VBIAS.n2 27.1064
R49 VBIAS.n75 VBIAS.n73 27.1064
R50 VBIAS.n80 VBIAS.n71 27.1064
R51 VBIAS.n85 VBIAS.n69 27.1064
R52 VBIAS.n90 VBIAS.n67 27.1064
R53 VBIAS.n95 VBIAS.n65 27.1064
R54 VBIAS.n100 VBIAS.n63 27.1064
R55 VBIAS.n105 VBIAS.n61 27.1064
R56 VBIAS.n22 VBIAS.t12 24.1005
R57 VBIAS.n27 VBIAS.t14 24.1005
R58 VBIAS.n33 VBIAS.t0 24.1005
R59 VBIAS.n38 VBIAS.t2 24.1005
R60 VBIAS.n44 VBIAS.t6 24.1005
R61 VBIAS.n49 VBIAS.t8 24.1005
R62 VBIAS.n55 VBIAS.t10 24.1005
R63 VBIAS.n76 VBIAS.t17 24.1005
R64 VBIAS.n81 VBIAS.t18 24.1005
R65 VBIAS.n86 VBIAS.t19 24.1005
R66 VBIAS.n91 VBIAS.t20 24.1005
R67 VBIAS.n96 VBIAS.t21 24.1005
R68 VBIAS.n101 VBIAS.t22 24.1005
R69 VBIAS.n106 VBIAS.t23 24.1005
R70 VBIAS.n108 VBIAS.n107 23.1301
R71 VBIAS.n24 VBIAS.n23 23.0638
R72 VBIAS.n29 VBIAS.n28 23.0638
R73 VBIAS.n35 VBIAS.n34 23.0638
R74 VBIAS.n40 VBIAS.n39 23.0638
R75 VBIAS.n46 VBIAS.n45 23.0638
R76 VBIAS.n51 VBIAS.n50 23.0638
R77 VBIAS.n54 VBIAS.n53 23.0638
R78 VBIAS.n78 VBIAS.n77 23.0638
R79 VBIAS.n83 VBIAS.n82 23.0638
R80 VBIAS.n88 VBIAS.n87 23.0638
R81 VBIAS.n93 VBIAS.n92 23.0638
R82 VBIAS.n98 VBIAS.n97 23.0638
R83 VBIAS.n103 VBIAS.n102 23.0638
R84 VBIAS.n23 VBIAS.n17 11.3247
R85 VBIAS.n28 VBIAS.n15 11.3247
R86 VBIAS.n34 VBIAS.n12 11.3247
R87 VBIAS.n39 VBIAS.n10 11.3247
R88 VBIAS.n45 VBIAS.n7 11.3247
R89 VBIAS.n50 VBIAS.n5 11.3247
R90 VBIAS.n54 VBIAS.n2 11.3247
R91 VBIAS.n77 VBIAS.n73 11.3247
R92 VBIAS.n82 VBIAS.n71 11.3247
R93 VBIAS.n87 VBIAS.n69 11.3247
R94 VBIAS.n92 VBIAS.n67 11.3247
R95 VBIAS.n97 VBIAS.n65 11.3247
R96 VBIAS.n102 VBIAS.n63 11.3247
R97 VBIAS.n107 VBIAS.n61 11.3247
R98 VBIAS.n57 VBIAS.n56 9.36679
R99 VBIAS.n2 VBIAS.n1 9.3005
R100 VBIAS.n48 VBIAS.n47 9.3005
R101 VBIAS.n5 VBIAS.n4 9.3005
R102 VBIAS.n43 VBIAS.n42 9.3005
R103 VBIAS.n7 VBIAS.n6 9.3005
R104 VBIAS.n37 VBIAS.n36 9.3005
R105 VBIAS.n10 VBIAS.n9 9.3005
R106 VBIAS.n32 VBIAS.n31 9.3005
R107 VBIAS.n12 VBIAS.n11 9.3005
R108 VBIAS.n26 VBIAS.n25 9.3005
R109 VBIAS.n15 VBIAS.n14 9.3005
R110 VBIAS.n21 VBIAS.n20 9.3005
R111 VBIAS.n17 VBIAS.n16 9.3005
R112 VBIAS.n105 VBIAS.n104 9.3005
R113 VBIAS.n61 VBIAS.n60 9.3005
R114 VBIAS.n100 VBIAS.n99 9.3005
R115 VBIAS.n63 VBIAS.n62 9.3005
R116 VBIAS.n95 VBIAS.n94 9.3005
R117 VBIAS.n65 VBIAS.n64 9.3005
R118 VBIAS.n90 VBIAS.n89 9.3005
R119 VBIAS.n67 VBIAS.n66 9.3005
R120 VBIAS.n85 VBIAS.n84 9.3005
R121 VBIAS.n69 VBIAS.n68 9.3005
R122 VBIAS.n80 VBIAS.n79 9.3005
R123 VBIAS.n71 VBIAS.n70 9.3005
R124 VBIAS.n75 VBIAS.n74 9.3005
R125 VBIAS.n73 VBIAS.n72 9.3005
R126 VBIAS.n110 VBIAS.n58 6.2073
R127 VBIAS.n109 VBIAS.n59 4.56105
R128 VBIAS.n58 VBIAS.n0 4.56099
R129 VBIAS.n58 VBIAS.n57 4.56013
R130 VBIAS.n109 VBIAS.n108 4.56007
R131 VBIAS.n110 VBIAS.n109 2.27332
R132 VBIAS.n47 VBIAS.n46 0.3755
R133 VBIAS.n36 VBIAS.n35 0.3755
R134 VBIAS.n25 VBIAS.n24 0.3755
R135 VBIAS.n99 VBIAS.n98 0.3755
R136 VBIAS.n94 VBIAS.n93 0.3755
R137 VBIAS.n89 VBIAS.n88 0.3755
R138 VBIAS.n84 VBIAS.n83 0.3755
R139 VBIAS.n79 VBIAS.n78 0.3755
R140 VBIAS.n104 VBIAS.n103 0.37397
R141 VBIAS VBIAS.n110 0.271106
R142 VBIAS.n41 VBIAS.n40 0.192808
R143 VBIAS.n30 VBIAS.n29 0.192808
R144 VBIAS.n52 VBIAS.n51 0.188
R145 VBIAS.n53 VBIAS.n52 0.18647
R146 VBIAS.n20 VBIAS.n19 0.185596
R147 VBIAS.n42 VBIAS.n41 0.183192
R148 VBIAS.n31 VBIAS.n30 0.183192
R149 VBIAS.n51 VBIAS.n4 0.173577
R150 VBIAS.n47 VBIAS.n4 0.173577
R151 VBIAS.n46 VBIAS.n6 0.173577
R152 VBIAS.n42 VBIAS.n6 0.173577
R153 VBIAS.n40 VBIAS.n9 0.173577
R154 VBIAS.n36 VBIAS.n9 0.173577
R155 VBIAS.n35 VBIAS.n11 0.173577
R156 VBIAS.n31 VBIAS.n11 0.173577
R157 VBIAS.n29 VBIAS.n14 0.173577
R158 VBIAS.n25 VBIAS.n14 0.173577
R159 VBIAS.n24 VBIAS.n16 0.173577
R160 VBIAS.n20 VBIAS.n16 0.173577
R161 VBIAS.n103 VBIAS.n62 0.173577
R162 VBIAS.n99 VBIAS.n62 0.173577
R163 VBIAS.n98 VBIAS.n64 0.173577
R164 VBIAS.n94 VBIAS.n64 0.173577
R165 VBIAS.n93 VBIAS.n66 0.173577
R166 VBIAS.n89 VBIAS.n66 0.173577
R167 VBIAS.n88 VBIAS.n68 0.173577
R168 VBIAS.n84 VBIAS.n68 0.173577
R169 VBIAS.n83 VBIAS.n70 0.173577
R170 VBIAS.n79 VBIAS.n70 0.173577
R171 VBIAS.n78 VBIAS.n72 0.173577
R172 VBIAS.n74 VBIAS.n72 0.173577
R173 VBIAS.n53 VBIAS.n0 0.0857273
R174 VBIAS.n104 VBIAS.n59 0.0857273
R175 VBIAS.n57 VBIAS.n1 0.0705758
R176 VBIAS.n108 VBIAS.n60 0.0705758
R177 VBIAS.n1 VBIAS.n0 0.0516364
R178 VBIAS.n60 VBIAS.n59 0.0516364
R179 D2.n7 D2.n6 103.209
R180 D2.n5 D2.n4 103.207
R181 D2.n3 D2.n2 103.207
R182 D2.n1 D2.n0 103.207
R183 D2.n0 D2.t2 30.0005
R184 D2.n0 D2.t7 30.0005
R185 D2.n2 D2.t1 30.0005
R186 D2.n2 D2.t3 30.0005
R187 D2.n4 D2.t5 30.0005
R188 D2.n4 D2.t6 30.0005
R189 D2.n6 D2.t4 30.0005
R190 D2.n6 D2.t0 30.0005
R191 D2.n8 D2.n1 24.6824
R192 D2.n8 D2.n7 8.14496
R193 D2 D2.n8 1.77113
R194 D2.n7 D2.n5 1.44839
R195 D2.n3 D2.n1 1.43886
R196 D2.n5 D2.n3 1.43644
R197 VINM.n10 VINM.n9 184.74
R198 VINM.n23 VINM.n22 184.74
R199 VINM.n29 VINM.n28 184.74
R200 VINM.n41 VINM.n40 184.74
R201 VINM.n52 VINM.n51 184.74
R202 VINM.n63 VINM.n62 184.74
R203 VINM.n75 VINM.n74 184.74
R204 VINM.n31 VINM.t3 85.0431
R205 VINM.n11 VINM.n10 77.1778
R206 VINM.n24 VINM.n23 77.1778
R207 VINM.n30 VINM.n29 77.1778
R208 VINM.n42 VINM.n41 77.1778
R209 VINM.n53 VINM.n52 77.1778
R210 VINM.n64 VINM.n63 77.1778
R211 VINM.n74 VINM.n73 77.1778
R212 VINM.n12 VINM.n9 27.1064
R213 VINM.n22 VINM.n5 27.1064
R214 VINM.n28 VINM.n3 27.1064
R215 VINM.n40 VINM.n38 27.1064
R216 VINM.n51 VINM.n49 27.1064
R217 VINM.n62 VINM.n60 27.1064
R218 VINM.n75 VINM.n71 27.1064
R219 VINM.n10 VINM.t0 24.1005
R220 VINM.n23 VINM.t1 24.1005
R221 VINM.n29 VINM.t2 24.1005
R222 VINM.n41 VINM.t4 24.1005
R223 VINM.n52 VINM.t5 24.1005
R224 VINM.n63 VINM.t6 24.1005
R225 VINM.n74 VINM.t7 24.1005
R226 VINM.n54 VINM.n53 23.1414
R227 VINM.n65 VINM.n64 23.1414
R228 VINM.n43 VINM.n42 23.1377
R229 VINM.n73 VINM.n72 23.1377
R230 VINM.n11 VINM.n6 23.0638
R231 VINM.n25 VINM.n24 23.0638
R232 VINM.n31 VINM.n30 23.0638
R233 VINM.n12 VINM.n11 11.3247
R234 VINM.n24 VINM.n5 11.3247
R235 VINM.n30 VINM.n3 11.3247
R236 VINM.n42 VINM.n38 11.3247
R237 VINM.n53 VINM.n49 11.3247
R238 VINM.n64 VINM.n60 11.3247
R239 VINM.n73 VINM.n71 11.3247
R240 VINM.n40 VINM.n39 9.37815
R241 VINM.n76 VINM.n75 9.37815
R242 VINM.n9 VINM.n8 9.37626
R243 VINM.n51 VINM.n50 9.37436
R244 VINM.n62 VINM.n61 9.37436
R245 VINM.n28 VINM.n27 9.3005
R246 VINM.n3 VINM.n2 9.3005
R247 VINM.n22 VINM.n21 9.3005
R248 VINM.n7 VINM.n5 9.3005
R249 VINM.n13 VINM.n12 9.3005
R250 VINM.n38 VINM.n37 9.3005
R251 VINM.n49 VINM.n48 9.3005
R252 VINM.n60 VINM.n59 9.3005
R253 VINM.n71 VINM.n70 9.3005
R254 VINM.n15 VINM.n8 4.56105
R255 VINM.n15 VINM.n14 4.56007
R256 VINM.n33 VINM.n32 4.5005
R257 VINM.n26 VINM.n1 4.5005
R258 VINM.n18 VINM.n4 4.5005
R259 VINM.n20 VINM.n19 4.5005
R260 VINM.n39 VINM.n36 4.5005
R261 VINM.n44 VINM.n43 4.5005
R262 VINM.n50 VINM.n47 4.5005
R263 VINM.n55 VINM.n54 4.5005
R264 VINM.n61 VINM.n58 4.5005
R265 VINM.n66 VINM.n65 4.5005
R266 VINM.n77 VINM.n76 4.5005
R267 VINM.n72 VINM.n69 4.5005
R268 VINM.n18 VINM.n17 3.42565
R269 VINM.n19 VINM.n16 3.42565
R270 VINM.n34 VINM.n33 3.42565
R271 VINM.n1 VINM.n0 3.42565
R272 VINM.n45 VINM.n44 3.42565
R273 VINM.n36 VINM.n35 3.42565
R274 VINM.n56 VINM.n55 3.42565
R275 VINM.n47 VINM.n46 3.42565
R276 VINM.n67 VINM.n66 3.42565
R277 VINM.n58 VINM.n57 3.42565
R278 VINM.n78 VINM.n77 3.42565
R279 VINM.n69 VINM.n68 3.42565
R280 VINM.n16 VINM.n15 1.85459
R281 VINM VINM.n78 0.850773
R282 VINM.n35 VINM.n34 0.369379
R283 VINM.n27 VINM.n25 0.295955
R284 VINM.n21 VINM.n6 0.295955
R285 VINM.n17 VINM.n0 0.159303
R286 VINM.n68 VINM.n67 0.157167
R287 VINM.n57 VINM.n56 0.157167
R288 VINM.n46 VINM.n45 0.155742
R289 VINM.n19 VINM.n18 0.121712
R290 VINM.n33 VINM.n1 0.121712
R291 VINM.n44 VINM.n36 0.121712
R292 VINM.n55 VINM.n47 0.121712
R293 VINM.n66 VINM.n58 0.121712
R294 VINM.n77 VINM.n69 0.121712
R295 VINM.n27 VINM.n26 0.0819394
R296 VINM.n25 VINM.n4 0.0762576
R297 VINM.n21 VINM.n20 0.0762576
R298 VINM.n14 VINM.n6 0.0762576
R299 VINM.n32 VINM.n31 0.0705758
R300 VINM.n32 VINM.n2 0.0667879
R301 VINM.n43 VINM.n37 0.063
R302 VINM.n50 VINM.n48 0.063
R303 VINM.n61 VINM.n59 0.063
R304 VINM.n72 VINM.n70 0.063
R305 VINM.n7 VINM.n4 0.0611061
R306 VINM.n20 VINM.n7 0.0611061
R307 VINM.n14 VINM.n13 0.0611061
R308 VINM.n13 VINM.n8 0.0611061
R309 VINM.n39 VINM.n37 0.0592121
R310 VINM.n54 VINM.n48 0.0592121
R311 VINM.n65 VINM.n59 0.0592121
R312 VINM.n76 VINM.n70 0.0592121
R313 VINM.n78 VINM.n68 0.0574697
R314 VINM.n67 VINM.n57 0.0574697
R315 VINM.n56 VINM.n46 0.0574697
R316 VINM.n45 VINM.n35 0.0574697
R317 VINM.n34 VINM.n0 0.0574697
R318 VINM.n17 VINM.n16 0.0574697
R319 VINM.n26 VINM.n2 0.0554242
R320 D1.n1 D1.n0 103.037
R321 D1.n3 D1.n2 103.035
R322 D1.n5 D1.n4 103.035
R323 D1.n7 D1.n6 103.035
R324 D1.n6 D1.t5 30.0005
R325 D1.n6 D1.t6 30.0005
R326 D1.n4 D1.t3 30.0005
R327 D1.n4 D1.t7 30.0005
R328 D1.n2 D1.t0 30.0005
R329 D1.n2 D1.t2 30.0005
R330 D1.n0 D1.t1 30.0005
R331 D1.n0 D1.t4 30.0005
R332 D1.n8 D1.n7 23.6693
R333 D1.n8 D1.n1 6.09179
R334 D1 D1.n8 1.90501
R335 D1.n7 D1.n5 1.44843
R336 D1.n3 D1.n1 1.43884
R337 D1.n5 D1.n3 1.43641
R338 VINP.n18 VINP.n17 184.74
R339 VINP.n28 VINP.n27 184.74
R340 VINP.n39 VINP.n38 184.74
R341 VINP.n50 VINP.n49 184.74
R342 VINP.n61 VINP.n60 184.74
R343 VINP.n66 VINP.n65 184.74
R344 VINP.n80 VINP.n79 184.74
R345 VINP.n87 VINP.n86 184.74
R346 VINP.n19 VINP.n18 77.1778
R347 VINP.n29 VINP.n28 77.1778
R348 VINP.n40 VINP.n39 77.1778
R349 VINP.n51 VINP.n50 77.1778
R350 VINP.n62 VINP.n61 77.1778
R351 VINP.n67 VINP.n66 77.1778
R352 VINP.n81 VINP.n80 77.1778
R353 VINP.n86 VINP.n85 77.1778
R354 VINP.n17 VINP.n16 27.1064
R355 VINP.n27 VINP.n25 27.1064
R356 VINP.n38 VINP.n36 27.1064
R357 VINP.n49 VINP.n47 27.1064
R358 VINP.n60 VINP.n12 27.1064
R359 VINP.n68 VINP.n65 27.1064
R360 VINP.n79 VINP.n5 27.1064
R361 VINP.n87 VINP.n3 27.1064
R362 VINP.n18 VINP.t0 24.1005
R363 VINP.n28 VINP.t1 24.1005
R364 VINP.n39 VINP.t2 24.1005
R365 VINP.n50 VINP.t3 24.1005
R366 VINP.n61 VINP.t4 24.1005
R367 VINP.n66 VINP.t5 24.1005
R368 VINP.n80 VINP.t6 24.1005
R369 VINP.n86 VINP.t7 24.1005
R370 VINP.n52 VINP.n51 23.1452
R371 VINP.n20 VINP.n19 23.1396
R372 VINP.n30 VINP.n29 23.1396
R373 VINP.n41 VINP.n40 23.1339
R374 VINP.n63 VINP.n62 23.0638
R375 VINP.n67 VINP.n6 23.0638
R376 VINP.n82 VINP.n81 23.0638
R377 VINP.n85 VINP.n84 23.0638
R378 VINP.n19 VINP.n16 11.3247
R379 VINP.n29 VINP.n25 11.3247
R380 VINP.n40 VINP.n36 11.3247
R381 VINP.n51 VINP.n47 11.3247
R382 VINP.n62 VINP.n12 11.3247
R383 VINP.n68 VINP.n67 11.3247
R384 VINP.n81 VINP.n5 11.3247
R385 VINP.n85 VINP.n3 11.3247
R386 VINP.n38 VINP.n37 9.38194
R387 VINP.n60 VINP.n59 9.38194
R388 VINP.n17 VINP.n14 9.37626
R389 VINP.n27 VINP.n26 9.37626
R390 VINP.n49 VINP.n48 9.37058
R391 VINP.n88 VINP.n87 9.36489
R392 VINP.n16 VINP.n15 9.3005
R393 VINP.n25 VINP.n24 9.3005
R394 VINP.n36 VINP.n35 9.3005
R395 VINP.n47 VINP.n46 9.3005
R396 VINP.n3 VINP.n2 9.3005
R397 VINP.n79 VINP.n78 9.3005
R398 VINP.n7 VINP.n5 9.3005
R399 VINP.n65 VINP.n64 9.3005
R400 VINP.n69 VINP.n68 9.3005
R401 VINP.n13 VINP.n12 9.3005
R402 VINP.n21 VINP.n14 4.56105
R403 VINP.n21 VINP.n20 4.56007
R404 VINP.n26 VINP.n23 4.5005
R405 VINP.n31 VINP.n30 4.5005
R406 VINP.n42 VINP.n41 4.5005
R407 VINP.n37 VINP.n34 4.5005
R408 VINP.n48 VINP.n45 4.5005
R409 VINP.n53 VINP.n52 4.5005
R410 VINP.n57 VINP.n11 4.5005
R411 VINP.n59 VINP.n58 4.5005
R412 VINP.n89 VINP.n88 4.5005
R413 VINP.n83 VINP.n1 4.5005
R414 VINP.n75 VINP.n4 4.5005
R415 VINP.n77 VINP.n76 4.5005
R416 VINP.n71 VINP.n70 4.5005
R417 VINP.n10 VINP.n9 4.5005
R418 VINP.n32 VINP.n31 3.42565
R419 VINP.n23 VINP.n22 3.42565
R420 VINP.n43 VINP.n42 3.42565
R421 VINP.n34 VINP.n33 3.42565
R422 VINP.n54 VINP.n53 3.42565
R423 VINP.n45 VINP.n44 3.42565
R424 VINP.n57 VINP.n56 3.42565
R425 VINP.n58 VINP.n55 3.42565
R426 VINP.n72 VINP.n71 3.42565
R427 VINP.n9 VINP.n8 3.42565
R428 VINP.n75 VINP.n74 3.42565
R429 VINP.n76 VINP.n73 3.42565
R430 VINP.n90 VINP.n89 3.42565
R431 VINP.n1 VINP.n0 3.42565
R432 VINP.n22 VINP.n21 1.85459
R433 VINP VINP.n90 0.845788
R434 VINP.n84 VINP.n82 0.295955
R435 VINP.n78 VINP.n6 0.295955
R436 VINP.n64 VINP.n63 0.295955
R437 VINP.n74 VINP.n0 0.161439
R438 VINP.n55 VINP.n54 0.161439
R439 VINP.n33 VINP.n32 0.159303
R440 VINP.n73 VINP.n72 0.157879
R441 VINP.n56 VINP.n8 0.154318
R442 VINP.n44 VINP.n43 0.152894
R443 VINP.n31 VINP.n23 0.121712
R444 VINP.n42 VINP.n34 0.121712
R445 VINP.n53 VINP.n45 0.121712
R446 VINP.n58 VINP.n57 0.121712
R447 VINP.n71 VINP.n9 0.121712
R448 VINP.n76 VINP.n75 0.121712
R449 VINP.n89 VINP.n1 0.121712
R450 VINP.n84 VINP.n83 0.0876212
R451 VINP.n70 VINP.n6 0.0781515
R452 VINP.n82 VINP.n4 0.0762576
R453 VINP.n78 VINP.n77 0.0762576
R454 VINP.n64 VINP.n10 0.0743636
R455 VINP.n88 VINP.n2 0.0724697
R456 VINP.n63 VINP.n11 0.0705758
R457 VINP.n41 VINP.n35 0.0667879
R458 VINP.n48 VINP.n46 0.0667879
R459 VINP.n13 VINP.n11 0.0667879
R460 VINP.n69 VINP.n10 0.063
R461 VINP.n20 VINP.n15 0.0611061
R462 VINP.n15 VINP.n14 0.0611061
R463 VINP.n30 VINP.n24 0.0611061
R464 VINP.n26 VINP.n24 0.0611061
R465 VINP.n7 VINP.n4 0.0611061
R466 VINP.n77 VINP.n7 0.0611061
R467 VINP.n70 VINP.n69 0.0592121
R468 VINP.n90 VINP.n0 0.0574697
R469 VINP.n74 VINP.n73 0.0574697
R470 VINP.n72 VINP.n8 0.0574697
R471 VINP.n56 VINP.n55 0.0574697
R472 VINP.n54 VINP.n44 0.0574697
R473 VINP.n43 VINP.n33 0.0574697
R474 VINP.n32 VINP.n22 0.0574697
R475 VINP.n37 VINP.n35 0.0554242
R476 VINP.n52 VINP.n46 0.0554242
R477 VINP.n59 VINP.n13 0.0554242
R478 VINP.n83 VINP.n2 0.0497424
R479 VGND.n614 VGND.n325 723.761
R480 VGND.n939 VGND.n10 723.761
R481 VGND.n941 VGND.n3 698.066
R482 VGND.n612 VGND.n328 698.066
R483 VGND.n583 VGND.n582 585
R484 VGND.n433 VGND.n341 585
R485 VGND.n435 VGND.n434 585
R486 VGND.n431 VGND.n344 585
R487 VGND.n430 VGND.n326 585
R488 VGND.n430 VGND.n429 585
R489 VGND.n346 VGND.n345 585
R490 VGND.n425 VGND.n424 585
R491 VGND.n422 VGND.n348 585
R492 VGND.n420 VGND.n419 585
R493 VGND.n349 VGND.n326 585
R494 VGND.n350 VGND.n349 585
R495 VGND.n415 VGND.n414 585
R496 VGND.n412 VGND.n352 585
R497 VGND.n411 VGND.n353 585
R498 VGND.n409 VGND.n408 585
R499 VGND.n355 VGND.n354 585
R500 VGND.n403 VGND.n402 585
R501 VGND.n400 VGND.n326 585
R502 VGND.n400 VGND.n357 585
R503 VGND.n399 VGND.n358 585
R504 VGND.n397 VGND.n396 585
R505 VGND.n360 VGND.n359 585
R506 VGND.n391 VGND.n390 585
R507 VGND.n388 VGND.n326 585
R508 VGND.n388 VGND.n362 585
R509 VGND.n387 VGND.n386 585
R510 VGND.n367 VGND.n364 585
R511 VGND.n382 VGND.n381 585
R512 VGND.n379 VGND.n366 585
R513 VGND.n378 VGND.n368 585
R514 VGND.n376 VGND.n375 585
R515 VGND.n371 VGND.n370 585
R516 VGND.n325 VGND.n324 585
R517 VGND.n613 VGND.n327 585
R518 VGND.n578 VGND.n327 585
R519 VGND.n439 VGND.n319 585
R520 VGND.n577 VGND.n439 585
R521 VGND.n621 VGND.n320 585
R522 VGND.n576 VGND.n320 585
R523 VGND.n440 VGND.n312 585
R524 VGND.n441 VGND.n440 585
R525 VGND.n631 VGND.n313 585
R526 VGND.n572 VGND.n313 585
R527 VGND.n443 VGND.n305 585
R528 VGND.n571 VGND.n443 585
R529 VGND.n639 VGND.n306 585
R530 VGND.n570 VGND.n306 585
R531 VGND.n444 VGND.n298 585
R532 VGND.n445 VGND.n444 585
R533 VGND.n657 VGND.n299 585
R534 VGND.n566 VGND.n299 585
R535 VGND.n447 VGND.n290 585
R536 VGND.n565 VGND.n447 585
R537 VGND.n665 VGND.n291 585
R538 VGND.n564 VGND.n291 585
R539 VGND.n448 VGND.n292 585
R540 VGND.n449 VGND.n448 585
R541 VGND.n674 VGND.n284 585
R542 VGND.n560 VGND.n284 585
R543 VGND.n451 VGND.n276 585
R544 VGND.n559 VGND.n451 585
R545 VGND.n682 VGND.n277 585
R546 VGND.n558 VGND.n277 585
R547 VGND.n452 VGND.n278 585
R548 VGND.n453 VGND.n452 585
R549 VGND.n690 VGND.n267 585
R550 VGND.n554 VGND.n267 585
R551 VGND.n455 VGND.n259 585
R552 VGND.n553 VGND.n455 585
R553 VGND.n698 VGND.n260 585
R554 VGND.n552 VGND.n260 585
R555 VGND.n456 VGND.n261 585
R556 VGND.n457 VGND.n456 585
R557 VGND.n707 VGND.n253 585
R558 VGND.n548 VGND.n253 585
R559 VGND.n459 VGND.n245 585
R560 VGND.n547 VGND.n459 585
R561 VGND.n715 VGND.n246 585
R562 VGND.n546 VGND.n246 585
R563 VGND.n460 VGND.n247 585
R564 VGND.n461 VGND.n460 585
R565 VGND.n723 VGND.n236 585
R566 VGND.n542 VGND.n236 585
R567 VGND.n463 VGND.n228 585
R568 VGND.n541 VGND.n463 585
R569 VGND.n731 VGND.n229 585
R570 VGND.n540 VGND.n229 585
R571 VGND.n464 VGND.n230 585
R572 VGND.n465 VGND.n464 585
R573 VGND.n740 VGND.n222 585
R574 VGND.n536 VGND.n222 585
R575 VGND.n467 VGND.n214 585
R576 VGND.n535 VGND.n467 585
R577 VGND.n748 VGND.n215 585
R578 VGND.n534 VGND.n215 585
R579 VGND.n468 VGND.n216 585
R580 VGND.n469 VGND.n468 585
R581 VGND.n756 VGND.n205 585
R582 VGND.n530 VGND.n205 585
R583 VGND.n471 VGND.n198 585
R584 VGND.n529 VGND.n471 585
R585 VGND.n764 VGND.n199 585
R586 VGND.n528 VGND.n199 585
R587 VGND.n472 VGND.n191 585
R588 VGND.n473 VGND.n472 585
R589 VGND.n772 VGND.n192 585
R590 VGND.n524 VGND.n192 585
R591 VGND.n475 VGND.n184 585
R592 VGND.n523 VGND.n475 585
R593 VGND.n780 VGND.n185 585
R594 VGND.n522 VGND.n185 585
R595 VGND.n476 VGND.n177 585
R596 VGND.n477 VGND.n476 585
R597 VGND.n792 VGND.n178 585
R598 VGND.n518 VGND.n178 585
R599 VGND.n479 VGND.n170 585
R600 VGND.n517 VGND.n479 585
R601 VGND.n800 VGND.n171 585
R602 VGND.n516 VGND.n171 585
R603 VGND.n480 VGND.n163 585
R604 VGND.n481 VGND.n480 585
R605 VGND.n808 VGND.n164 585
R606 VGND.n512 VGND.n164 585
R607 VGND.n483 VGND.n156 585
R608 VGND.n511 VGND.n483 585
R609 VGND.n816 VGND.n157 585
R610 VGND.n510 VGND.n157 585
R611 VGND.n484 VGND.n149 585
R612 VGND.n485 VGND.n484 585
R613 VGND.n828 VGND.n150 585
R614 VGND.n506 VGND.n150 585
R615 VGND.n487 VGND.n142 585
R616 VGND.n505 VGND.n487 585
R617 VGND.n836 VGND.n143 585
R618 VGND.n504 VGND.n143 585
R619 VGND.n488 VGND.n135 585
R620 VGND.n489 VGND.n488 585
R621 VGND.n854 VGND.n136 585
R622 VGND.n500 VGND.n136 585
R623 VGND.n491 VGND.n128 585
R624 VGND.n499 VGND.n491 585
R625 VGND.n862 VGND.n129 585
R626 VGND.n498 VGND.n129 585
R627 VGND.n492 VGND.n119 585
R628 VGND.n493 VGND.n492 585
R629 VGND.n876 VGND.n120 585
R630 VGND.n494 VGND.n120 585
R631 VGND.n112 VGND.n110 585
R632 VGND.n110 VGND.n109 585
R633 VGND.n885 VGND.n884 585
R634 VGND.n886 VGND.n885 585
R635 VGND.n111 VGND.n6 585
R636 VGND.n111 VGND.n107 585
R637 VGND.n940 VGND.n7 585
R638 VGND.n890 VGND.n7 585
R639 VGND.n74 VGND.n8 585
R640 VGND.n106 VGND.n74 585
R641 VGND.n77 VGND.n75 585
R642 VGND.n102 VGND.n79 585
R643 VGND.n101 VGND.n80 585
R644 VGND.n100 VGND.n82 585
R645 VGND.n85 VGND.n83 585
R646 VGND.n96 VGND.n87 585
R647 VGND.n95 VGND.n88 585
R648 VGND.n94 VGND.n92 585
R649 VGND.n90 VGND.n2 585
R650 VGND.n943 VGND.n3 585
R651 VGND.n12 VGND.n10 585
R652 VGND.n934 VGND.n16 585
R653 VGND.n933 VGND.n17 585
R654 VGND.n932 VGND.n19 585
R655 VGND.n22 VGND.n20 585
R656 VGND.n928 VGND.n24 585
R657 VGND.n927 VGND.n25 585
R658 VGND.n926 VGND.n27 585
R659 VGND.n30 VGND.n28 585
R660 VGND.n922 VGND.n32 585
R661 VGND.n921 VGND.n33 585
R662 VGND.n920 VGND.n35 585
R663 VGND.n38 VGND.n36 585
R664 VGND.n916 VGND.n40 585
R665 VGND.n915 VGND.n41 585
R666 VGND.n914 VGND.n43 585
R667 VGND.n46 VGND.n44 585
R668 VGND.n910 VGND.n48 585
R669 VGND.n909 VGND.n49 585
R670 VGND.n908 VGND.n51 585
R671 VGND.n54 VGND.n52 585
R672 VGND.n904 VGND.n56 585
R673 VGND.n903 VGND.n57 585
R674 VGND.n902 VGND.n59 585
R675 VGND.n62 VGND.n60 585
R676 VGND.n898 VGND.n64 585
R677 VGND.n897 VGND.n65 585
R678 VGND.n896 VGND.n67 585
R679 VGND.n70 VGND.n68 585
R680 VGND.n892 VGND.n72 585
R681 VGND.n940 VGND.n939 585
R682 VGND.n939 VGND.n938 585
R683 VGND.n9 VGND.n6 585
R684 VGND.n11 VGND.n9 585
R685 VGND.n884 VGND.n883 585
R686 VGND.n883 VGND.n882 585
R687 VGND.n114 VGND.n112 585
R688 VGND.n115 VGND.n114 585
R689 VGND.n877 VGND.n876 585
R690 VGND.n878 VGND.n877 585
R691 VGND.n119 VGND.n118 585
R692 VGND.n118 VGND.n117 585
R693 VGND.n862 VGND.n861 585
R694 VGND.n861 VGND.n860 585
R695 VGND.n130 VGND.n128 585
R696 VGND.n131 VGND.n130 585
R697 VGND.n855 VGND.n854 585
R698 VGND.n856 VGND.n855 585
R699 VGND.n135 VGND.n134 585
R700 VGND.n134 VGND.n133 585
R701 VGND.n836 VGND.n835 585
R702 VGND.n835 VGND.n834 585
R703 VGND.n144 VGND.n142 585
R704 VGND.n145 VGND.n144 585
R705 VGND.n829 VGND.n828 585
R706 VGND.n830 VGND.n829 585
R707 VGND.n149 VGND.n148 585
R708 VGND.n148 VGND.n147 585
R709 VGND.n816 VGND.n815 585
R710 VGND.n815 VGND.n814 585
R711 VGND.n158 VGND.n156 585
R712 VGND.n159 VGND.n158 585
R713 VGND.n809 VGND.n808 585
R714 VGND.n810 VGND.n809 585
R715 VGND.n163 VGND.n162 585
R716 VGND.n162 VGND.n161 585
R717 VGND.n800 VGND.n799 585
R718 VGND.n799 VGND.n798 585
R719 VGND.n172 VGND.n170 585
R720 VGND.n173 VGND.n172 585
R721 VGND.n793 VGND.n792 585
R722 VGND.n794 VGND.n793 585
R723 VGND.n177 VGND.n176 585
R724 VGND.n176 VGND.n175 585
R725 VGND.n780 VGND.n779 585
R726 VGND.n779 VGND.n778 585
R727 VGND.n186 VGND.n184 585
R728 VGND.n187 VGND.n186 585
R729 VGND.n773 VGND.n772 585
R730 VGND.n774 VGND.n773 585
R731 VGND.n191 VGND.n190 585
R732 VGND.n190 VGND.n189 585
R733 VGND.n764 VGND.n763 585
R734 VGND.n763 VGND.n762 585
R735 VGND.n200 VGND.n198 585
R736 VGND.n201 VGND.n200 585
R737 VGND.n757 VGND.n756 585
R738 VGND.n758 VGND.n757 585
R739 VGND.n216 VGND.n204 585
R740 VGND.n204 VGND.n203 585
R741 VGND.n748 VGND.n747 585
R742 VGND.n747 VGND.n746 585
R743 VGND.n217 VGND.n214 585
R744 VGND.n218 VGND.n217 585
R745 VGND.n741 VGND.n740 585
R746 VGND.n742 VGND.n741 585
R747 VGND.n230 VGND.n221 585
R748 VGND.n221 VGND.n220 585
R749 VGND.n731 VGND.n730 585
R750 VGND.n730 VGND.n729 585
R751 VGND.n231 VGND.n228 585
R752 VGND.n232 VGND.n231 585
R753 VGND.n724 VGND.n723 585
R754 VGND.n725 VGND.n724 585
R755 VGND.n247 VGND.n235 585
R756 VGND.n235 VGND.n234 585
R757 VGND.n715 VGND.n714 585
R758 VGND.n714 VGND.n713 585
R759 VGND.n248 VGND.n245 585
R760 VGND.n249 VGND.n248 585
R761 VGND.n708 VGND.n707 585
R762 VGND.n709 VGND.n708 585
R763 VGND.n261 VGND.n252 585
R764 VGND.n252 VGND.n251 585
R765 VGND.n698 VGND.n697 585
R766 VGND.n697 VGND.n696 585
R767 VGND.n262 VGND.n259 585
R768 VGND.n263 VGND.n262 585
R769 VGND.n691 VGND.n690 585
R770 VGND.n692 VGND.n691 585
R771 VGND.n278 VGND.n266 585
R772 VGND.n266 VGND.n265 585
R773 VGND.n682 VGND.n681 585
R774 VGND.n681 VGND.n680 585
R775 VGND.n279 VGND.n276 585
R776 VGND.n280 VGND.n279 585
R777 VGND.n675 VGND.n674 585
R778 VGND.n676 VGND.n675 585
R779 VGND.n292 VGND.n283 585
R780 VGND.n283 VGND.n282 585
R781 VGND.n665 VGND.n664 585
R782 VGND.n664 VGND.n663 585
R783 VGND.n293 VGND.n290 585
R784 VGND.n294 VGND.n293 585
R785 VGND.n658 VGND.n657 585
R786 VGND.n659 VGND.n658 585
R787 VGND.n298 VGND.n297 585
R788 VGND.n297 VGND.n296 585
R789 VGND.n639 VGND.n638 585
R790 VGND.n638 VGND.n637 585
R791 VGND.n307 VGND.n305 585
R792 VGND.n308 VGND.n307 585
R793 VGND.n632 VGND.n631 585
R794 VGND.n633 VGND.n632 585
R795 VGND.n312 VGND.n311 585
R796 VGND.n311 VGND.n310 585
R797 VGND.n621 VGND.n620 585
R798 VGND.n620 VGND.n619 585
R799 VGND.n321 VGND.n319 585
R800 VGND.n322 VGND.n321 585
R801 VGND.n614 VGND.n613 585
R802 VGND.n615 VGND.n614 585
R803 VGND.n613 VGND.n612 585
R804 VGND.n612 VGND.n611 585
R805 VGND.n319 VGND.n318 585
R806 VGND.n318 VGND.n317 585
R807 VGND.n622 VGND.n621 585
R808 VGND.n623 VGND.n622 585
R809 VGND.n314 VGND.n312 585
R810 VGND.n315 VGND.n314 585
R811 VGND.n631 VGND.n630 585
R812 VGND.n630 VGND.n629 585
R813 VGND.n305 VGND.n304 585
R814 VGND.n304 VGND.n303 585
R815 VGND.n640 VGND.n639 585
R816 VGND.n641 VGND.n640 585
R817 VGND.n300 VGND.n298 585
R818 VGND.n301 VGND.n300 585
R819 VGND.n657 VGND.n656 585
R820 VGND.n656 VGND.n655 585
R821 VGND.n290 VGND.n289 585
R822 VGND.n289 VGND.n288 585
R823 VGND.n666 VGND.n665 585
R824 VGND.n667 VGND.n666 585
R825 VGND.n292 VGND.n285 585
R826 VGND.n286 VGND.n285 585
R827 VGND.n674 VGND.n673 585
R828 VGND.n673 VGND.n672 585
R829 VGND.n276 VGND.n275 585
R830 VGND.n275 VGND.n274 585
R831 VGND.n683 VGND.n682 585
R832 VGND.n684 VGND.n683 585
R833 VGND.n278 VGND.n268 585
R834 VGND.n269 VGND.n268 585
R835 VGND.n690 VGND.n689 585
R836 VGND.n689 VGND.n688 585
R837 VGND.n259 VGND.n258 585
R838 VGND.n258 VGND.n257 585
R839 VGND.n699 VGND.n698 585
R840 VGND.n700 VGND.n699 585
R841 VGND.n261 VGND.n254 585
R842 VGND.n255 VGND.n254 585
R843 VGND.n707 VGND.n706 585
R844 VGND.n706 VGND.n705 585
R845 VGND.n245 VGND.n244 585
R846 VGND.n244 VGND.n243 585
R847 VGND.n716 VGND.n715 585
R848 VGND.n717 VGND.n716 585
R849 VGND.n247 VGND.n237 585
R850 VGND.n238 VGND.n237 585
R851 VGND.n723 VGND.n722 585
R852 VGND.n722 VGND.n721 585
R853 VGND.n228 VGND.n227 585
R854 VGND.n227 VGND.n226 585
R855 VGND.n732 VGND.n731 585
R856 VGND.n733 VGND.n732 585
R857 VGND.n230 VGND.n223 585
R858 VGND.n224 VGND.n223 585
R859 VGND.n740 VGND.n739 585
R860 VGND.n739 VGND.n738 585
R861 VGND.n214 VGND.n213 585
R862 VGND.n213 VGND.n212 585
R863 VGND.n749 VGND.n748 585
R864 VGND.n750 VGND.n749 585
R865 VGND.n216 VGND.n206 585
R866 VGND.n207 VGND.n206 585
R867 VGND.n756 VGND.n755 585
R868 VGND.n755 VGND.n754 585
R869 VGND.n198 VGND.n197 585
R870 VGND.n197 VGND.n196 585
R871 VGND.n765 VGND.n764 585
R872 VGND.n766 VGND.n765 585
R873 VGND.n193 VGND.n191 585
R874 VGND.n194 VGND.n193 585
R875 VGND.n772 VGND.n771 585
R876 VGND.n771 VGND.n770 585
R877 VGND.n184 VGND.n183 585
R878 VGND.n183 VGND.n182 585
R879 VGND.n781 VGND.n780 585
R880 VGND.n782 VGND.n781 585
R881 VGND.n179 VGND.n177 585
R882 VGND.n180 VGND.n179 585
R883 VGND.n792 VGND.n791 585
R884 VGND.n791 VGND.n790 585
R885 VGND.n170 VGND.n169 585
R886 VGND.n169 VGND.n168 585
R887 VGND.n801 VGND.n800 585
R888 VGND.n802 VGND.n801 585
R889 VGND.n165 VGND.n163 585
R890 VGND.n166 VGND.n165 585
R891 VGND.n808 VGND.n807 585
R892 VGND.n807 VGND.n806 585
R893 VGND.n156 VGND.n155 585
R894 VGND.n155 VGND.n154 585
R895 VGND.n817 VGND.n816 585
R896 VGND.n818 VGND.n817 585
R897 VGND.n151 VGND.n149 585
R898 VGND.n152 VGND.n151 585
R899 VGND.n828 VGND.n827 585
R900 VGND.n827 VGND.n826 585
R901 VGND.n142 VGND.n141 585
R902 VGND.n141 VGND.n140 585
R903 VGND.n837 VGND.n836 585
R904 VGND.n838 VGND.n837 585
R905 VGND.n137 VGND.n135 585
R906 VGND.n138 VGND.n137 585
R907 VGND.n854 VGND.n853 585
R908 VGND.n853 VGND.n852 585
R909 VGND.n128 VGND.n127 585
R910 VGND.n127 VGND.n126 585
R911 VGND.n863 VGND.n862 585
R912 VGND.n864 VGND.n863 585
R913 VGND.n121 VGND.n119 585
R914 VGND.n123 VGND.n121 585
R915 VGND.n876 VGND.n875 585
R916 VGND.n875 VGND.n874 585
R917 VGND.n122 VGND.n112 585
R918 VGND.n124 VGND.n122 585
R919 VGND.n884 VGND.n113 585
R920 VGND.n870 VGND.n113 585
R921 VGND.n6 VGND.n5 585
R922 VGND.n5 VGND.n4 585
R923 VGND.n941 VGND.n940 585
R924 VGND.n942 VGND.n941 585
R925 VGND.n328 VGND.n326 585
R926 VGND.n329 VGND.n328 585
R927 VGND.n607 VGND.n606 585
R928 VGND.n604 VGND.n331 585
R929 VGND.n603 VGND.n326 585
R930 VGND.n603 VGND.n602 585
R931 VGND.n333 VGND.n332 585
R932 VGND.n598 VGND.n597 585
R933 VGND.n595 VGND.n326 585
R934 VGND.n595 VGND.n335 585
R935 VGND.n594 VGND.n593 585
R936 VGND.n587 VGND.n337 585
R937 VGND.n589 VGND.n588 585
R938 VGND.n585 VGND.n339 585
R939 VGND.n584 VGND.n583 453.957
R940 VGND.n73 VGND.n72 453.957
R941 VGND.n74 VGND.n73 428.262
R942 VGND.n585 VGND.n584 428.262
R943 VGND.n939 VGND.n9 308.349
R944 VGND.n883 VGND.n9 308.349
R945 VGND.n883 VGND.n114 308.349
R946 VGND.n877 VGND.n114 308.349
R947 VGND.n877 VGND.n118 308.349
R948 VGND.n861 VGND.n118 308.349
R949 VGND.n861 VGND.n130 308.349
R950 VGND.n855 VGND.n130 308.349
R951 VGND.n855 VGND.n134 308.349
R952 VGND.n835 VGND.n134 308.349
R953 VGND.n835 VGND.n144 308.349
R954 VGND.n829 VGND.n144 308.349
R955 VGND.n829 VGND.n148 308.349
R956 VGND.n815 VGND.n148 308.349
R957 VGND.n815 VGND.n158 308.349
R958 VGND.n809 VGND.n158 308.349
R959 VGND.n809 VGND.n162 308.349
R960 VGND.n799 VGND.n162 308.349
R961 VGND.n799 VGND.n172 308.349
R962 VGND.n793 VGND.n172 308.349
R963 VGND.n793 VGND.n176 308.349
R964 VGND.n779 VGND.n176 308.349
R965 VGND.n779 VGND.n186 308.349
R966 VGND.n773 VGND.n186 308.349
R967 VGND.n773 VGND.n190 308.349
R968 VGND.n763 VGND.n190 308.349
R969 VGND.n763 VGND.n200 308.349
R970 VGND.n757 VGND.n200 308.349
R971 VGND.n757 VGND.n204 308.349
R972 VGND.n747 VGND.n204 308.349
R973 VGND.n747 VGND.n217 308.349
R974 VGND.n741 VGND.n217 308.349
R975 VGND.n741 VGND.n221 308.349
R976 VGND.n730 VGND.n221 308.349
R977 VGND.n730 VGND.n231 308.349
R978 VGND.n724 VGND.n231 308.349
R979 VGND.n724 VGND.n235 308.349
R980 VGND.n714 VGND.n235 308.349
R981 VGND.n714 VGND.n248 308.349
R982 VGND.n708 VGND.n248 308.349
R983 VGND.n708 VGND.n252 308.349
R984 VGND.n697 VGND.n252 308.349
R985 VGND.n697 VGND.n262 308.349
R986 VGND.n691 VGND.n262 308.349
R987 VGND.n691 VGND.n266 308.349
R988 VGND.n681 VGND.n266 308.349
R989 VGND.n681 VGND.n279 308.349
R990 VGND.n675 VGND.n279 308.349
R991 VGND.n675 VGND.n283 308.349
R992 VGND.n664 VGND.n283 308.349
R993 VGND.n664 VGND.n293 308.349
R994 VGND.n658 VGND.n293 308.349
R995 VGND.n658 VGND.n297 308.349
R996 VGND.n638 VGND.n297 308.349
R997 VGND.n638 VGND.n307 308.349
R998 VGND.n632 VGND.n307 308.349
R999 VGND.n632 VGND.n311 308.349
R1000 VGND.n620 VGND.n311 308.349
R1001 VGND.n620 VGND.n321 308.349
R1002 VGND.n614 VGND.n321 308.349
R1003 VGND.n434 VGND.n433 308.349
R1004 VGND.n431 VGND.n430 308.349
R1005 VGND.n430 VGND.n345 308.349
R1006 VGND.n424 VGND.n422 308.349
R1007 VGND.n420 VGND.n349 308.349
R1008 VGND.n414 VGND.n349 308.349
R1009 VGND.n412 VGND.n411 308.349
R1010 VGND.n409 VGND.n354 308.349
R1011 VGND.n402 VGND.n400 308.349
R1012 VGND.n400 VGND.n399 308.349
R1013 VGND.n397 VGND.n359 308.349
R1014 VGND.n390 VGND.n388 308.349
R1015 VGND.n388 VGND.n387 308.349
R1016 VGND.n381 VGND.n367 308.349
R1017 VGND.n379 VGND.n378 308.349
R1018 VGND.n376 VGND.n370 308.349
R1019 VGND.n111 VGND.n7 308.349
R1020 VGND.n885 VGND.n111 308.349
R1021 VGND.n885 VGND.n110 308.349
R1022 VGND.n120 VGND.n110 308.349
R1023 VGND.n492 VGND.n120 308.349
R1024 VGND.n492 VGND.n129 308.349
R1025 VGND.n491 VGND.n129 308.349
R1026 VGND.n491 VGND.n136 308.349
R1027 VGND.n488 VGND.n136 308.349
R1028 VGND.n488 VGND.n143 308.349
R1029 VGND.n487 VGND.n143 308.349
R1030 VGND.n487 VGND.n150 308.349
R1031 VGND.n484 VGND.n150 308.349
R1032 VGND.n484 VGND.n157 308.349
R1033 VGND.n483 VGND.n157 308.349
R1034 VGND.n483 VGND.n164 308.349
R1035 VGND.n480 VGND.n164 308.349
R1036 VGND.n480 VGND.n171 308.349
R1037 VGND.n479 VGND.n171 308.349
R1038 VGND.n479 VGND.n178 308.349
R1039 VGND.n476 VGND.n178 308.349
R1040 VGND.n476 VGND.n185 308.349
R1041 VGND.n475 VGND.n185 308.349
R1042 VGND.n475 VGND.n192 308.349
R1043 VGND.n472 VGND.n192 308.349
R1044 VGND.n472 VGND.n199 308.349
R1045 VGND.n471 VGND.n199 308.349
R1046 VGND.n471 VGND.n205 308.349
R1047 VGND.n468 VGND.n205 308.349
R1048 VGND.n468 VGND.n215 308.349
R1049 VGND.n467 VGND.n215 308.349
R1050 VGND.n467 VGND.n222 308.349
R1051 VGND.n464 VGND.n222 308.349
R1052 VGND.n464 VGND.n229 308.349
R1053 VGND.n463 VGND.n229 308.349
R1054 VGND.n463 VGND.n236 308.349
R1055 VGND.n460 VGND.n236 308.349
R1056 VGND.n460 VGND.n246 308.349
R1057 VGND.n459 VGND.n246 308.349
R1058 VGND.n459 VGND.n253 308.349
R1059 VGND.n456 VGND.n253 308.349
R1060 VGND.n456 VGND.n260 308.349
R1061 VGND.n455 VGND.n260 308.349
R1062 VGND.n455 VGND.n267 308.349
R1063 VGND.n452 VGND.n267 308.349
R1064 VGND.n452 VGND.n277 308.349
R1065 VGND.n451 VGND.n277 308.349
R1066 VGND.n451 VGND.n284 308.349
R1067 VGND.n448 VGND.n284 308.349
R1068 VGND.n448 VGND.n291 308.349
R1069 VGND.n447 VGND.n291 308.349
R1070 VGND.n447 VGND.n299 308.349
R1071 VGND.n444 VGND.n299 308.349
R1072 VGND.n444 VGND.n306 308.349
R1073 VGND.n443 VGND.n306 308.349
R1074 VGND.n443 VGND.n313 308.349
R1075 VGND.n440 VGND.n313 308.349
R1076 VGND.n440 VGND.n320 308.349
R1077 VGND.n439 VGND.n320 308.349
R1078 VGND.n439 VGND.n327 308.349
R1079 VGND.n92 VGND.n90 308.349
R1080 VGND.n88 VGND.n87 308.349
R1081 VGND.n85 VGND.n82 308.349
R1082 VGND.n80 VGND.n79 308.349
R1083 VGND.n77 VGND.n74 308.349
R1084 VGND.n70 VGND.n67 308.349
R1085 VGND.n65 VGND.n64 308.349
R1086 VGND.n62 VGND.n59 308.349
R1087 VGND.n57 VGND.n56 308.349
R1088 VGND.n54 VGND.n51 308.349
R1089 VGND.n49 VGND.n48 308.349
R1090 VGND.n46 VGND.n43 308.349
R1091 VGND.n41 VGND.n40 308.349
R1092 VGND.n38 VGND.n35 308.349
R1093 VGND.n33 VGND.n32 308.349
R1094 VGND.n30 VGND.n27 308.349
R1095 VGND.n25 VGND.n24 308.349
R1096 VGND.n22 VGND.n19 308.349
R1097 VGND.n17 VGND.n16 308.349
R1098 VGND.n941 VGND.n5 308.349
R1099 VGND.n113 VGND.n5 308.349
R1100 VGND.n122 VGND.n113 308.349
R1101 VGND.n875 VGND.n122 308.349
R1102 VGND.n875 VGND.n121 308.349
R1103 VGND.n863 VGND.n121 308.349
R1104 VGND.n863 VGND.n127 308.349
R1105 VGND.n853 VGND.n127 308.349
R1106 VGND.n853 VGND.n137 308.349
R1107 VGND.n837 VGND.n137 308.349
R1108 VGND.n837 VGND.n141 308.349
R1109 VGND.n827 VGND.n141 308.349
R1110 VGND.n827 VGND.n151 308.349
R1111 VGND.n817 VGND.n151 308.349
R1112 VGND.n817 VGND.n155 308.349
R1113 VGND.n807 VGND.n155 308.349
R1114 VGND.n807 VGND.n165 308.349
R1115 VGND.n801 VGND.n165 308.349
R1116 VGND.n801 VGND.n169 308.349
R1117 VGND.n791 VGND.n169 308.349
R1118 VGND.n791 VGND.n179 308.349
R1119 VGND.n781 VGND.n179 308.349
R1120 VGND.n781 VGND.n183 308.349
R1121 VGND.n771 VGND.n183 308.349
R1122 VGND.n771 VGND.n193 308.349
R1123 VGND.n765 VGND.n193 308.349
R1124 VGND.n765 VGND.n197 308.349
R1125 VGND.n755 VGND.n197 308.349
R1126 VGND.n755 VGND.n206 308.349
R1127 VGND.n749 VGND.n206 308.349
R1128 VGND.n749 VGND.n213 308.349
R1129 VGND.n739 VGND.n213 308.349
R1130 VGND.n739 VGND.n223 308.349
R1131 VGND.n732 VGND.n223 308.349
R1132 VGND.n732 VGND.n227 308.349
R1133 VGND.n722 VGND.n227 308.349
R1134 VGND.n722 VGND.n237 308.349
R1135 VGND.n716 VGND.n237 308.349
R1136 VGND.n716 VGND.n244 308.349
R1137 VGND.n706 VGND.n244 308.349
R1138 VGND.n706 VGND.n254 308.349
R1139 VGND.n699 VGND.n254 308.349
R1140 VGND.n699 VGND.n258 308.349
R1141 VGND.n689 VGND.n258 308.349
R1142 VGND.n689 VGND.n268 308.349
R1143 VGND.n683 VGND.n268 308.349
R1144 VGND.n683 VGND.n275 308.349
R1145 VGND.n673 VGND.n275 308.349
R1146 VGND.n673 VGND.n285 308.349
R1147 VGND.n666 VGND.n285 308.349
R1148 VGND.n666 VGND.n289 308.349
R1149 VGND.n656 VGND.n289 308.349
R1150 VGND.n656 VGND.n300 308.349
R1151 VGND.n640 VGND.n300 308.349
R1152 VGND.n640 VGND.n304 308.349
R1153 VGND.n630 VGND.n304 308.349
R1154 VGND.n630 VGND.n314 308.349
R1155 VGND.n622 VGND.n314 308.349
R1156 VGND.n622 VGND.n318 308.349
R1157 VGND.n612 VGND.n318 308.349
R1158 VGND.n606 VGND.n328 308.349
R1159 VGND.n604 VGND.n603 308.349
R1160 VGND.n603 VGND.n332 308.349
R1161 VGND.n597 VGND.n595 308.349
R1162 VGND.n595 VGND.n594 308.349
R1163 VGND.n588 VGND.n587 308.349
R1164 VGND.n73 VGND.n7 269.805
R1165 VGND.n584 VGND.n327 269.805
R1166 VGND.n340 VGND.n326 231.493
R1167 VGND.n432 VGND.n326 231.493
R1168 VGND.n423 VGND.n326 231.493
R1169 VGND.n421 VGND.n326 231.493
R1170 VGND.n413 VGND.n326 231.493
R1171 VGND.n410 VGND.n326 231.493
R1172 VGND.n401 VGND.n326 231.493
R1173 VGND.n398 VGND.n326 231.493
R1174 VGND.n389 VGND.n326 231.493
R1175 VGND.n363 VGND.n326 231.493
R1176 VGND.n380 VGND.n326 231.493
R1177 VGND.n377 VGND.n326 231.493
R1178 VGND.n369 VGND.n326 231.493
R1179 VGND.n78 VGND.n8 231.493
R1180 VGND.n81 VGND.n8 231.493
R1181 VGND.n86 VGND.n8 231.493
R1182 VGND.n91 VGND.n8 231.493
R1183 VGND.n89 VGND.n8 231.493
R1184 VGND.n15 VGND.n8 231.493
R1185 VGND.n18 VGND.n8 231.493
R1186 VGND.n23 VGND.n8 231.493
R1187 VGND.n26 VGND.n8 231.493
R1188 VGND.n31 VGND.n8 231.493
R1189 VGND.n34 VGND.n8 231.493
R1190 VGND.n39 VGND.n8 231.493
R1191 VGND.n42 VGND.n8 231.493
R1192 VGND.n47 VGND.n8 231.493
R1193 VGND.n50 VGND.n8 231.493
R1194 VGND.n55 VGND.n8 231.493
R1195 VGND.n58 VGND.n8 231.493
R1196 VGND.n63 VGND.n8 231.493
R1197 VGND.n66 VGND.n8 231.493
R1198 VGND.n71 VGND.n8 231.493
R1199 VGND.n605 VGND.n326 231.493
R1200 VGND.n596 VGND.n326 231.493
R1201 VGND.n336 VGND.n326 231.493
R1202 VGND.n586 VGND.n326 231.493
R1203 VGND.n626 VGND.t38 130.113
R1204 VGND.n866 VGND.t30 130.103
R1205 VGND.n626 VGND.t50 129.376
R1206 VGND.n866 VGND.t42 129.376
R1207 VGND.n433 VGND.n340 122.017
R1208 VGND.n432 VGND.n431 122.017
R1209 VGND.n424 VGND.n423 122.017
R1210 VGND.n421 VGND.n420 122.017
R1211 VGND.n413 VGND.n412 122.017
R1212 VGND.n411 VGND.n410 122.017
R1213 VGND.n402 VGND.n401 122.017
R1214 VGND.n399 VGND.n398 122.017
R1215 VGND.n390 VGND.n389 122.017
R1216 VGND.n367 VGND.n363 122.017
R1217 VGND.n381 VGND.n380 122.017
R1218 VGND.n378 VGND.n377 122.017
R1219 VGND.n370 VGND.n369 122.017
R1220 VGND.n78 VGND.n77 122.017
R1221 VGND.n81 VGND.n80 122.017
R1222 VGND.n86 VGND.n85 122.017
R1223 VGND.n92 VGND.n91 122.017
R1224 VGND.n90 VGND.n89 122.017
R1225 VGND.n15 VGND.n10 122.017
R1226 VGND.n18 VGND.n17 122.017
R1227 VGND.n23 VGND.n22 122.017
R1228 VGND.n26 VGND.n25 122.017
R1229 VGND.n31 VGND.n30 122.017
R1230 VGND.n34 VGND.n33 122.017
R1231 VGND.n39 VGND.n38 122.017
R1232 VGND.n42 VGND.n41 122.017
R1233 VGND.n47 VGND.n46 122.017
R1234 VGND.n50 VGND.n49 122.017
R1235 VGND.n55 VGND.n54 122.017
R1236 VGND.n58 VGND.n57 122.017
R1237 VGND.n63 VGND.n62 122.017
R1238 VGND.n66 VGND.n65 122.017
R1239 VGND.n71 VGND.n70 122.017
R1240 VGND.n583 VGND.n340 122.017
R1241 VGND.n434 VGND.n432 122.017
R1242 VGND.n423 VGND.n345 122.017
R1243 VGND.n422 VGND.n421 122.017
R1244 VGND.n414 VGND.n413 122.017
R1245 VGND.n410 VGND.n409 122.017
R1246 VGND.n401 VGND.n354 122.017
R1247 VGND.n398 VGND.n397 122.017
R1248 VGND.n389 VGND.n359 122.017
R1249 VGND.n387 VGND.n363 122.017
R1250 VGND.n380 VGND.n379 122.017
R1251 VGND.n377 VGND.n376 122.017
R1252 VGND.n369 VGND.n325 122.017
R1253 VGND.n89 VGND.n3 122.017
R1254 VGND.n91 VGND.n88 122.017
R1255 VGND.n87 VGND.n86 122.017
R1256 VGND.n82 VGND.n81 122.017
R1257 VGND.n79 VGND.n78 122.017
R1258 VGND.n72 VGND.n71 122.017
R1259 VGND.n67 VGND.n66 122.017
R1260 VGND.n64 VGND.n63 122.017
R1261 VGND.n59 VGND.n58 122.017
R1262 VGND.n56 VGND.n55 122.017
R1263 VGND.n51 VGND.n50 122.017
R1264 VGND.n48 VGND.n47 122.017
R1265 VGND.n43 VGND.n42 122.017
R1266 VGND.n40 VGND.n39 122.017
R1267 VGND.n35 VGND.n34 122.017
R1268 VGND.n32 VGND.n31 122.017
R1269 VGND.n27 VGND.n26 122.017
R1270 VGND.n24 VGND.n23 122.017
R1271 VGND.n19 VGND.n18 122.017
R1272 VGND.n16 VGND.n15 122.017
R1273 VGND.n605 VGND.n604 122.017
R1274 VGND.n597 VGND.n596 122.017
R1275 VGND.n587 VGND.n336 122.017
R1276 VGND.n586 VGND.n585 122.017
R1277 VGND.n606 VGND.n605 122.017
R1278 VGND.n596 VGND.n332 122.017
R1279 VGND.n594 VGND.n336 122.017
R1280 VGND.n588 VGND.n586 122.017
R1281 VGND.n272 VGND.n270 100.114
R1282 VGND.n241 VGND.n239 100.114
R1283 VGND.n210 VGND.n208 100.114
R1284 VGND.n786 VGND.n784 100.114
R1285 VGND.n822 VGND.n820 100.114
R1286 VGND.n272 VGND.n271 99.3764
R1287 VGND.n241 VGND.n240 99.3764
R1288 VGND.n210 VGND.n209 99.3764
R1289 VGND.n786 VGND.n785 99.3764
R1290 VGND.n822 VGND.n821 99.3764
R1291 VGND.n646 VGND.n645 97.1573
R1292 VGND.n842 VGND.n841 97.1573
R1293 VGND.n651 VGND.n650 97.1253
R1294 VGND.n847 VGND.n846 97.1253
R1295 VGND.n940 VGND.n6 92.9037
R1296 VGND.n884 VGND.n6 92.9037
R1297 VGND.n884 VGND.n112 92.9037
R1298 VGND.n876 VGND.n112 92.9037
R1299 VGND.n876 VGND.n119 92.9037
R1300 VGND.n862 VGND.n119 92.9037
R1301 VGND.n862 VGND.n128 92.9037
R1302 VGND.n854 VGND.n135 92.9037
R1303 VGND.n836 VGND.n135 92.9037
R1304 VGND.n836 VGND.n142 92.9037
R1305 VGND.n828 VGND.n149 92.9037
R1306 VGND.n816 VGND.n149 92.9037
R1307 VGND.n816 VGND.n156 92.9037
R1308 VGND.n808 VGND.n163 92.9037
R1309 VGND.n800 VGND.n163 92.9037
R1310 VGND.n800 VGND.n170 92.9037
R1311 VGND.n792 VGND.n177 92.9037
R1312 VGND.n780 VGND.n177 92.9037
R1313 VGND.n780 VGND.n184 92.9037
R1314 VGND.n772 VGND.n191 92.9037
R1315 VGND.n764 VGND.n191 92.9037
R1316 VGND.n764 VGND.n198 92.9037
R1317 VGND.n756 VGND.n198 92.9037
R1318 VGND.n748 VGND.n216 92.9037
R1319 VGND.n748 VGND.n214 92.9037
R1320 VGND.n740 VGND.n214 92.9037
R1321 VGND.n731 VGND.n230 92.9037
R1322 VGND.n731 VGND.n228 92.9037
R1323 VGND.n723 VGND.n228 92.9037
R1324 VGND.n715 VGND.n247 92.9037
R1325 VGND.n715 VGND.n245 92.9037
R1326 VGND.n707 VGND.n245 92.9037
R1327 VGND.n698 VGND.n261 92.9037
R1328 VGND.n698 VGND.n259 92.9037
R1329 VGND.n690 VGND.n259 92.9037
R1330 VGND.n682 VGND.n278 92.9037
R1331 VGND.n682 VGND.n276 92.9037
R1332 VGND.n674 VGND.n276 92.9037
R1333 VGND.n665 VGND.n292 92.9037
R1334 VGND.n665 VGND.n290 92.9037
R1335 VGND.n657 VGND.n290 92.9037
R1336 VGND.n657 VGND.n298 92.9037
R1337 VGND.n639 VGND.n305 92.9037
R1338 VGND.n631 VGND.n305 92.9037
R1339 VGND.n631 VGND.n312 92.9037
R1340 VGND.n621 VGND.n312 92.9037
R1341 VGND.n621 VGND.n319 92.9037
R1342 VGND.n613 VGND.n319 92.9037
R1343 VGND.t8 VGND.n184 85.1618
R1344 VGND.n216 VGND.t2 85.1618
R1345 VGND.n674 VGND.t9 85.1618
R1346 VGND.n639 VGND.t3 85.1618
R1347 VGND.n648 VGND.t49 84.9593
R1348 VGND.n644 VGND.t37 84.9593
R1349 VGND.n840 VGND.t31 84.9569
R1350 VGND.n840 VGND.t28 84.9533
R1351 VGND.n648 VGND.t46 84.9508
R1352 VGND.n644 VGND.t34 84.9508
R1353 VGND.n844 VGND.t43 84.923
R1354 VGND.n844 VGND.t40 84.9198
R1355 VGND.n940 VGND.n8 81.2908
R1356 VGND.n613 VGND.n326 81.2908
R1357 VGND.n854 VGND.t11 69.6779
R1358 VGND.t7 VGND.n170 69.6779
R1359 VGND.n230 VGND.t5 69.6779
R1360 VGND.n690 VGND.t0 69.6779
R1361 VGND.n828 VGND.t10 54.194
R1362 VGND.t6 VGND.n156 54.194
R1363 VGND.n247 VGND.t4 54.194
R1364 VGND.n707 VGND.t1 54.194
R1365 VGND.n938 VGND.n12 47.0266
R1366 VGND.n615 VGND.n324 47.0266
R1367 VGND.n943 VGND.n942 45.357
R1368 VGND.n611 VGND.n329 45.357
R1369 VGND.t10 VGND.n142 38.7102
R1370 VGND.n808 VGND.t6 38.7102
R1371 VGND.n723 VGND.t4 38.7102
R1372 VGND.n261 VGND.t1 38.7102
R1373 VGND.n650 VGND.t47 30.0005
R1374 VGND.n650 VGND.t51 30.0005
R1375 VGND.n645 VGND.t35 30.0005
R1376 VGND.n645 VGND.t39 30.0005
R1377 VGND.n271 VGND.t27 30.0005
R1378 VGND.n271 VGND.t48 30.0005
R1379 VGND.n270 VGND.t21 30.0005
R1380 VGND.n270 VGND.t36 30.0005
R1381 VGND.n240 VGND.t12 30.0005
R1382 VGND.n240 VGND.t26 30.0005
R1383 VGND.n239 VGND.t19 30.0005
R1384 VGND.n239 VGND.t20 30.0005
R1385 VGND.n209 VGND.t23 30.0005
R1386 VGND.n209 VGND.t25 30.0005
R1387 VGND.n208 VGND.t17 30.0005
R1388 VGND.n208 VGND.t18 30.0005
R1389 VGND.n785 VGND.t22 30.0005
R1390 VGND.n785 VGND.t24 30.0005
R1391 VGND.n784 VGND.t15 30.0005
R1392 VGND.n784 VGND.t16 30.0005
R1393 VGND.n821 VGND.t44 30.0005
R1394 VGND.n821 VGND.t13 30.0005
R1395 VGND.n820 VGND.t32 30.0005
R1396 VGND.n820 VGND.t14 30.0005
R1397 VGND.n846 VGND.t41 30.0005
R1398 VGND.n846 VGND.t45 30.0005
R1399 VGND.n841 VGND.t29 30.0005
R1400 VGND.n841 VGND.t33 30.0005
R1401 VGND.n582 VGND.n342 29.4962
R1402 VGND.n892 VGND.n891 29.4962
R1403 VGND.n891 VGND.n106 27.8266
R1404 VGND.n342 VGND.n339 27.8266
R1405 VGND.t11 VGND.n128 23.2263
R1406 VGND.n792 VGND.t7 23.2263
R1407 VGND.n740 VGND.t5 23.2263
R1408 VGND.n278 VGND.t0 23.2263
R1409 VGND.n582 VGND.n341 20.0353
R1410 VGND.n435 VGND.n341 20.0353
R1411 VGND.n435 VGND.n344 20.0353
R1412 VGND.n429 VGND.n344 20.0353
R1413 VGND.n429 VGND.n346 20.0353
R1414 VGND.n425 VGND.n346 20.0353
R1415 VGND.n425 VGND.n348 20.0353
R1416 VGND.n419 VGND.n348 20.0353
R1417 VGND.n419 VGND.n350 20.0353
R1418 VGND.n415 VGND.n350 20.0353
R1419 VGND.n415 VGND.n352 20.0353
R1420 VGND.n353 VGND.n352 20.0353
R1421 VGND.n408 VGND.n353 20.0353
R1422 VGND.n408 VGND.n355 20.0353
R1423 VGND.n403 VGND.n355 20.0353
R1424 VGND.n403 VGND.n357 20.0353
R1425 VGND.n358 VGND.n357 20.0353
R1426 VGND.n396 VGND.n358 20.0353
R1427 VGND.n396 VGND.n360 20.0353
R1428 VGND.n391 VGND.n360 20.0353
R1429 VGND.n391 VGND.n362 20.0353
R1430 VGND.n386 VGND.n362 20.0353
R1431 VGND.n386 VGND.n364 20.0353
R1432 VGND.n382 VGND.n364 20.0353
R1433 VGND.n382 VGND.n366 20.0353
R1434 VGND.n368 VGND.n366 20.0353
R1435 VGND.n375 VGND.n368 20.0353
R1436 VGND.n375 VGND.n371 20.0353
R1437 VGND.n371 VGND.n324 20.0353
R1438 VGND.n890 VGND.n107 20.0353
R1439 VGND.n886 VGND.n107 20.0353
R1440 VGND.n886 VGND.n109 20.0353
R1441 VGND.n494 VGND.n109 20.0353
R1442 VGND.n494 VGND.n493 20.0353
R1443 VGND.n498 VGND.n493 20.0353
R1444 VGND.n499 VGND.n498 20.0353
R1445 VGND.n500 VGND.n499 20.0353
R1446 VGND.n500 VGND.n489 20.0353
R1447 VGND.n504 VGND.n489 20.0353
R1448 VGND.n505 VGND.n504 20.0353
R1449 VGND.n506 VGND.n505 20.0353
R1450 VGND.n506 VGND.n485 20.0353
R1451 VGND.n510 VGND.n485 20.0353
R1452 VGND.n511 VGND.n510 20.0353
R1453 VGND.n512 VGND.n511 20.0353
R1454 VGND.n512 VGND.n481 20.0353
R1455 VGND.n516 VGND.n481 20.0353
R1456 VGND.n517 VGND.n516 20.0353
R1457 VGND.n518 VGND.n517 20.0353
R1458 VGND.n518 VGND.n477 20.0353
R1459 VGND.n522 VGND.n477 20.0353
R1460 VGND.n523 VGND.n522 20.0353
R1461 VGND.n524 VGND.n523 20.0353
R1462 VGND.n524 VGND.n473 20.0353
R1463 VGND.n528 VGND.n473 20.0353
R1464 VGND.n529 VGND.n528 20.0353
R1465 VGND.n530 VGND.n529 20.0353
R1466 VGND.n530 VGND.n469 20.0353
R1467 VGND.n534 VGND.n469 20.0353
R1468 VGND.n535 VGND.n534 20.0353
R1469 VGND.n536 VGND.n535 20.0353
R1470 VGND.n536 VGND.n465 20.0353
R1471 VGND.n540 VGND.n465 20.0353
R1472 VGND.n541 VGND.n540 20.0353
R1473 VGND.n542 VGND.n541 20.0353
R1474 VGND.n542 VGND.n461 20.0353
R1475 VGND.n546 VGND.n461 20.0353
R1476 VGND.n547 VGND.n546 20.0353
R1477 VGND.n548 VGND.n547 20.0353
R1478 VGND.n548 VGND.n457 20.0353
R1479 VGND.n552 VGND.n457 20.0353
R1480 VGND.n553 VGND.n552 20.0353
R1481 VGND.n554 VGND.n553 20.0353
R1482 VGND.n554 VGND.n453 20.0353
R1483 VGND.n558 VGND.n453 20.0353
R1484 VGND.n559 VGND.n558 20.0353
R1485 VGND.n560 VGND.n559 20.0353
R1486 VGND.n560 VGND.n449 20.0353
R1487 VGND.n564 VGND.n449 20.0353
R1488 VGND.n565 VGND.n564 20.0353
R1489 VGND.n566 VGND.n565 20.0353
R1490 VGND.n566 VGND.n445 20.0353
R1491 VGND.n570 VGND.n445 20.0353
R1492 VGND.n571 VGND.n570 20.0353
R1493 VGND.n572 VGND.n571 20.0353
R1494 VGND.n572 VGND.n441 20.0353
R1495 VGND.n576 VGND.n441 20.0353
R1496 VGND.n577 VGND.n576 20.0353
R1497 VGND.n578 VGND.n577 20.0353
R1498 VGND.n943 VGND.n2 20.0353
R1499 VGND.n94 VGND.n2 20.0353
R1500 VGND.n95 VGND.n94 20.0353
R1501 VGND.n96 VGND.n95 20.0353
R1502 VGND.n96 VGND.n83 20.0353
R1503 VGND.n100 VGND.n83 20.0353
R1504 VGND.n101 VGND.n100 20.0353
R1505 VGND.n102 VGND.n101 20.0353
R1506 VGND.n102 VGND.n75 20.0353
R1507 VGND.n106 VGND.n75 20.0353
R1508 VGND.n892 VGND.n68 20.0353
R1509 VGND.n896 VGND.n68 20.0353
R1510 VGND.n897 VGND.n896 20.0353
R1511 VGND.n898 VGND.n897 20.0353
R1512 VGND.n898 VGND.n60 20.0353
R1513 VGND.n902 VGND.n60 20.0353
R1514 VGND.n903 VGND.n902 20.0353
R1515 VGND.n904 VGND.n903 20.0353
R1516 VGND.n904 VGND.n52 20.0353
R1517 VGND.n908 VGND.n52 20.0353
R1518 VGND.n909 VGND.n908 20.0353
R1519 VGND.n910 VGND.n909 20.0353
R1520 VGND.n910 VGND.n44 20.0353
R1521 VGND.n914 VGND.n44 20.0353
R1522 VGND.n915 VGND.n914 20.0353
R1523 VGND.n916 VGND.n915 20.0353
R1524 VGND.n916 VGND.n36 20.0353
R1525 VGND.n920 VGND.n36 20.0353
R1526 VGND.n921 VGND.n920 20.0353
R1527 VGND.n922 VGND.n921 20.0353
R1528 VGND.n922 VGND.n28 20.0353
R1529 VGND.n926 VGND.n28 20.0353
R1530 VGND.n927 VGND.n926 20.0353
R1531 VGND.n928 VGND.n927 20.0353
R1532 VGND.n928 VGND.n20 20.0353
R1533 VGND.n932 VGND.n20 20.0353
R1534 VGND.n933 VGND.n932 20.0353
R1535 VGND.n934 VGND.n933 20.0353
R1536 VGND.n934 VGND.n12 20.0353
R1537 VGND.n938 VGND.n11 20.0353
R1538 VGND.n882 VGND.n11 20.0353
R1539 VGND.n882 VGND.n115 20.0353
R1540 VGND.n878 VGND.n115 20.0353
R1541 VGND.n878 VGND.n117 20.0353
R1542 VGND.n860 VGND.n117 20.0353
R1543 VGND.n860 VGND.n131 20.0353
R1544 VGND.n856 VGND.n131 20.0353
R1545 VGND.n856 VGND.n133 20.0353
R1546 VGND.n834 VGND.n133 20.0353
R1547 VGND.n834 VGND.n145 20.0353
R1548 VGND.n830 VGND.n145 20.0353
R1549 VGND.n830 VGND.n147 20.0353
R1550 VGND.n814 VGND.n147 20.0353
R1551 VGND.n814 VGND.n159 20.0353
R1552 VGND.n810 VGND.n159 20.0353
R1553 VGND.n810 VGND.n161 20.0353
R1554 VGND.n798 VGND.n161 20.0353
R1555 VGND.n798 VGND.n173 20.0353
R1556 VGND.n794 VGND.n173 20.0353
R1557 VGND.n794 VGND.n175 20.0353
R1558 VGND.n778 VGND.n175 20.0353
R1559 VGND.n778 VGND.n187 20.0353
R1560 VGND.n774 VGND.n187 20.0353
R1561 VGND.n774 VGND.n189 20.0353
R1562 VGND.n762 VGND.n189 20.0353
R1563 VGND.n762 VGND.n201 20.0353
R1564 VGND.n758 VGND.n201 20.0353
R1565 VGND.n758 VGND.n203 20.0353
R1566 VGND.n746 VGND.n203 20.0353
R1567 VGND.n746 VGND.n218 20.0353
R1568 VGND.n742 VGND.n218 20.0353
R1569 VGND.n742 VGND.n220 20.0353
R1570 VGND.n729 VGND.n220 20.0353
R1571 VGND.n729 VGND.n232 20.0353
R1572 VGND.n725 VGND.n232 20.0353
R1573 VGND.n725 VGND.n234 20.0353
R1574 VGND.n713 VGND.n234 20.0353
R1575 VGND.n713 VGND.n249 20.0353
R1576 VGND.n709 VGND.n249 20.0353
R1577 VGND.n709 VGND.n251 20.0353
R1578 VGND.n696 VGND.n251 20.0353
R1579 VGND.n696 VGND.n263 20.0353
R1580 VGND.n692 VGND.n263 20.0353
R1581 VGND.n692 VGND.n265 20.0353
R1582 VGND.n680 VGND.n265 20.0353
R1583 VGND.n680 VGND.n280 20.0353
R1584 VGND.n676 VGND.n280 20.0353
R1585 VGND.n676 VGND.n282 20.0353
R1586 VGND.n663 VGND.n282 20.0353
R1587 VGND.n663 VGND.n294 20.0353
R1588 VGND.n659 VGND.n294 20.0353
R1589 VGND.n659 VGND.n296 20.0353
R1590 VGND.n637 VGND.n296 20.0353
R1591 VGND.n637 VGND.n308 20.0353
R1592 VGND.n633 VGND.n308 20.0353
R1593 VGND.n633 VGND.n310 20.0353
R1594 VGND.n619 VGND.n310 20.0353
R1595 VGND.n619 VGND.n322 20.0353
R1596 VGND.n615 VGND.n322 20.0353
R1597 VGND.n607 VGND.n329 20.0353
R1598 VGND.n607 VGND.n331 20.0353
R1599 VGND.n602 VGND.n331 20.0353
R1600 VGND.n602 VGND.n333 20.0353
R1601 VGND.n598 VGND.n333 20.0353
R1602 VGND.n598 VGND.n335 20.0353
R1603 VGND.n593 VGND.n335 20.0353
R1604 VGND.n593 VGND.n337 20.0353
R1605 VGND.n589 VGND.n337 20.0353
R1606 VGND.n589 VGND.n339 20.0353
R1607 VGND.n942 VGND.n4 20.0353
R1608 VGND.n870 VGND.n4 20.0353
R1609 VGND.n870 VGND.n124 20.0353
R1610 VGND.n874 VGND.n124 20.0353
R1611 VGND.n874 VGND.n123 20.0353
R1612 VGND.n864 VGND.n123 20.0353
R1613 VGND.n864 VGND.n126 20.0353
R1614 VGND.n852 VGND.n126 20.0353
R1615 VGND.n852 VGND.n138 20.0353
R1616 VGND.n838 VGND.n138 20.0353
R1617 VGND.n838 VGND.n140 20.0353
R1618 VGND.n826 VGND.n140 20.0353
R1619 VGND.n826 VGND.n152 20.0353
R1620 VGND.n818 VGND.n152 20.0353
R1621 VGND.n818 VGND.n154 20.0353
R1622 VGND.n806 VGND.n154 20.0353
R1623 VGND.n806 VGND.n166 20.0353
R1624 VGND.n802 VGND.n166 20.0353
R1625 VGND.n802 VGND.n168 20.0353
R1626 VGND.n790 VGND.n168 20.0353
R1627 VGND.n790 VGND.n180 20.0353
R1628 VGND.n782 VGND.n180 20.0353
R1629 VGND.n782 VGND.n182 20.0353
R1630 VGND.n770 VGND.n182 20.0353
R1631 VGND.n770 VGND.n194 20.0353
R1632 VGND.n766 VGND.n194 20.0353
R1633 VGND.n766 VGND.n196 20.0353
R1634 VGND.n754 VGND.n196 20.0353
R1635 VGND.n754 VGND.n207 20.0353
R1636 VGND.n750 VGND.n207 20.0353
R1637 VGND.n750 VGND.n212 20.0353
R1638 VGND.n738 VGND.n212 20.0353
R1639 VGND.n738 VGND.n224 20.0353
R1640 VGND.n733 VGND.n224 20.0353
R1641 VGND.n733 VGND.n226 20.0353
R1642 VGND.n721 VGND.n226 20.0353
R1643 VGND.n721 VGND.n238 20.0353
R1644 VGND.n717 VGND.n238 20.0353
R1645 VGND.n717 VGND.n243 20.0353
R1646 VGND.n705 VGND.n243 20.0353
R1647 VGND.n705 VGND.n255 20.0353
R1648 VGND.n700 VGND.n255 20.0353
R1649 VGND.n700 VGND.n257 20.0353
R1650 VGND.n688 VGND.n257 20.0353
R1651 VGND.n688 VGND.n269 20.0353
R1652 VGND.n684 VGND.n269 20.0353
R1653 VGND.n684 VGND.n274 20.0353
R1654 VGND.n672 VGND.n274 20.0353
R1655 VGND.n672 VGND.n286 20.0353
R1656 VGND.n667 VGND.n286 20.0353
R1657 VGND.n667 VGND.n288 20.0353
R1658 VGND.n655 VGND.n288 20.0353
R1659 VGND.n655 VGND.n301 20.0353
R1660 VGND.n641 VGND.n301 20.0353
R1661 VGND.n641 VGND.n303 20.0353
R1662 VGND.n629 VGND.n303 20.0353
R1663 VGND.n629 VGND.n315 20.0353
R1664 VGND.n623 VGND.n315 20.0353
R1665 VGND.n623 VGND.n317 20.0353
R1666 VGND.n611 VGND.n317 20.0353
R1667 VGND.n891 VGND.n890 17.5309
R1668 VGND.n578 VGND.n342 17.5309
R1669 VGND.n611 VGND.n610 9.3005
R1670 VGND.n317 VGND.n316 9.3005
R1671 VGND.n624 VGND.n623 9.3005
R1672 VGND.n625 VGND.n315 9.3005
R1673 VGND.n629 VGND.n628 9.3005
R1674 VGND.n303 VGND.n302 9.3005
R1675 VGND.n642 VGND.n641 9.3005
R1676 VGND.n643 VGND.n301 9.3005
R1677 VGND.n655 VGND.n654 9.3005
R1678 VGND.n288 VGND.n287 9.3005
R1679 VGND.n668 VGND.n667 9.3005
R1680 VGND.n669 VGND.n286 9.3005
R1681 VGND.n672 VGND.n671 9.3005
R1682 VGND.n670 VGND.n274 9.3005
R1683 VGND.n685 VGND.n684 9.3005
R1684 VGND.n686 VGND.n269 9.3005
R1685 VGND.n688 VGND.n687 9.3005
R1686 VGND.n257 VGND.n256 9.3005
R1687 VGND.n701 VGND.n700 9.3005
R1688 VGND.n702 VGND.n255 9.3005
R1689 VGND.n705 VGND.n704 9.3005
R1690 VGND.n703 VGND.n243 9.3005
R1691 VGND.n718 VGND.n717 9.3005
R1692 VGND.n719 VGND.n238 9.3005
R1693 VGND.n721 VGND.n720 9.3005
R1694 VGND.n226 VGND.n225 9.3005
R1695 VGND.n734 VGND.n733 9.3005
R1696 VGND.n735 VGND.n224 9.3005
R1697 VGND.n738 VGND.n737 9.3005
R1698 VGND.n736 VGND.n212 9.3005
R1699 VGND.n751 VGND.n750 9.3005
R1700 VGND.n752 VGND.n207 9.3005
R1701 VGND.n754 VGND.n753 9.3005
R1702 VGND.n196 VGND.n195 9.3005
R1703 VGND.n767 VGND.n766 9.3005
R1704 VGND.n768 VGND.n194 9.3005
R1705 VGND.n770 VGND.n769 9.3005
R1706 VGND.n182 VGND.n181 9.3005
R1707 VGND.n783 VGND.n782 9.3005
R1708 VGND.n788 VGND.n180 9.3005
R1709 VGND.n790 VGND.n789 9.3005
R1710 VGND.n168 VGND.n167 9.3005
R1711 VGND.n803 VGND.n802 9.3005
R1712 VGND.n804 VGND.n166 9.3005
R1713 VGND.n806 VGND.n805 9.3005
R1714 VGND.n154 VGND.n153 9.3005
R1715 VGND.n819 VGND.n818 9.3005
R1716 VGND.n824 VGND.n152 9.3005
R1717 VGND.n826 VGND.n825 9.3005
R1718 VGND.n140 VGND.n139 9.3005
R1719 VGND.n839 VGND.n838 9.3005
R1720 VGND.n850 VGND.n138 9.3005
R1721 VGND.n852 VGND.n851 9.3005
R1722 VGND.n126 VGND.n125 9.3005
R1723 VGND.n865 VGND.n864 9.3005
R1724 VGND.n868 VGND.n123 9.3005
R1725 VGND.n874 VGND.n873 9.3005
R1726 VGND.n872 VGND.n124 9.3005
R1727 VGND.n871 VGND.n870 9.3005
R1728 VGND.n869 VGND.n4 9.3005
R1729 VGND.n942 VGND.n1 9.3005
R1730 VGND.n944 VGND.n943 9.3005
R1731 VGND.n609 VGND.n329 9.3005
R1732 VGND.n608 VGND.n607 9.3005
R1733 VGND.n331 VGND.n330 9.3005
R1734 VGND.n602 VGND.n601 9.3005
R1735 VGND.n600 VGND.n333 9.3005
R1736 VGND.n599 VGND.n598 9.3005
R1737 VGND.n335 VGND.n334 9.3005
R1738 VGND.n593 VGND.n592 9.3005
R1739 VGND.n591 VGND.n337 9.3005
R1740 VGND.n590 VGND.n589 9.3005
R1741 VGND.n339 VGND.n338 9.3005
R1742 VGND.n579 VGND.n578 9.3005
R1743 VGND.n577 VGND.n438 9.3005
R1744 VGND.n576 VGND.n575 9.3005
R1745 VGND.n574 VGND.n441 9.3005
R1746 VGND.n573 VGND.n572 9.3005
R1747 VGND.n571 VGND.n442 9.3005
R1748 VGND.n570 VGND.n569 9.3005
R1749 VGND.n568 VGND.n445 9.3005
R1750 VGND.n567 VGND.n566 9.3005
R1751 VGND.n565 VGND.n446 9.3005
R1752 VGND.n564 VGND.n563 9.3005
R1753 VGND.n562 VGND.n449 9.3005
R1754 VGND.n561 VGND.n560 9.3005
R1755 VGND.n559 VGND.n450 9.3005
R1756 VGND.n558 VGND.n557 9.3005
R1757 VGND.n556 VGND.n453 9.3005
R1758 VGND.n555 VGND.n554 9.3005
R1759 VGND.n553 VGND.n454 9.3005
R1760 VGND.n552 VGND.n551 9.3005
R1761 VGND.n550 VGND.n457 9.3005
R1762 VGND.n549 VGND.n548 9.3005
R1763 VGND.n547 VGND.n458 9.3005
R1764 VGND.n546 VGND.n545 9.3005
R1765 VGND.n544 VGND.n461 9.3005
R1766 VGND.n543 VGND.n542 9.3005
R1767 VGND.n541 VGND.n462 9.3005
R1768 VGND.n540 VGND.n539 9.3005
R1769 VGND.n538 VGND.n465 9.3005
R1770 VGND.n537 VGND.n536 9.3005
R1771 VGND.n535 VGND.n466 9.3005
R1772 VGND.n534 VGND.n533 9.3005
R1773 VGND.n532 VGND.n469 9.3005
R1774 VGND.n531 VGND.n530 9.3005
R1775 VGND.n529 VGND.n470 9.3005
R1776 VGND.n528 VGND.n527 9.3005
R1777 VGND.n526 VGND.n473 9.3005
R1778 VGND.n525 VGND.n524 9.3005
R1779 VGND.n523 VGND.n474 9.3005
R1780 VGND.n522 VGND.n521 9.3005
R1781 VGND.n520 VGND.n477 9.3005
R1782 VGND.n519 VGND.n518 9.3005
R1783 VGND.n517 VGND.n478 9.3005
R1784 VGND.n516 VGND.n515 9.3005
R1785 VGND.n514 VGND.n481 9.3005
R1786 VGND.n513 VGND.n512 9.3005
R1787 VGND.n511 VGND.n482 9.3005
R1788 VGND.n510 VGND.n509 9.3005
R1789 VGND.n508 VGND.n485 9.3005
R1790 VGND.n507 VGND.n506 9.3005
R1791 VGND.n505 VGND.n486 9.3005
R1792 VGND.n504 VGND.n503 9.3005
R1793 VGND.n502 VGND.n489 9.3005
R1794 VGND.n501 VGND.n500 9.3005
R1795 VGND.n499 VGND.n490 9.3005
R1796 VGND.n498 VGND.n497 9.3005
R1797 VGND.n496 VGND.n493 9.3005
R1798 VGND.n495 VGND.n494 9.3005
R1799 VGND.n109 VGND.n108 9.3005
R1800 VGND.n887 VGND.n886 9.3005
R1801 VGND.n888 VGND.n107 9.3005
R1802 VGND.n890 VGND.n889 9.3005
R1803 VGND.n106 VGND.n105 9.3005
R1804 VGND.n104 VGND.n75 9.3005
R1805 VGND.n103 VGND.n102 9.3005
R1806 VGND.n101 VGND.n76 9.3005
R1807 VGND.n100 VGND.n99 9.3005
R1808 VGND.n98 VGND.n83 9.3005
R1809 VGND.n97 VGND.n96 9.3005
R1810 VGND.n95 VGND.n84 9.3005
R1811 VGND.n94 VGND.n93 9.3005
R1812 VGND.n2 VGND.n0 9.3005
R1813 VGND.n936 VGND.n12 9.3005
R1814 VGND.n935 VGND.n934 9.3005
R1815 VGND.n933 VGND.n14 9.3005
R1816 VGND.n932 VGND.n931 9.3005
R1817 VGND.n930 VGND.n20 9.3005
R1818 VGND.n929 VGND.n928 9.3005
R1819 VGND.n927 VGND.n21 9.3005
R1820 VGND.n926 VGND.n925 9.3005
R1821 VGND.n924 VGND.n28 9.3005
R1822 VGND.n923 VGND.n922 9.3005
R1823 VGND.n921 VGND.n29 9.3005
R1824 VGND.n920 VGND.n919 9.3005
R1825 VGND.n918 VGND.n36 9.3005
R1826 VGND.n917 VGND.n916 9.3005
R1827 VGND.n915 VGND.n37 9.3005
R1828 VGND.n914 VGND.n913 9.3005
R1829 VGND.n912 VGND.n44 9.3005
R1830 VGND.n911 VGND.n910 9.3005
R1831 VGND.n909 VGND.n45 9.3005
R1832 VGND.n908 VGND.n907 9.3005
R1833 VGND.n906 VGND.n52 9.3005
R1834 VGND.n905 VGND.n904 9.3005
R1835 VGND.n903 VGND.n53 9.3005
R1836 VGND.n902 VGND.n901 9.3005
R1837 VGND.n900 VGND.n60 9.3005
R1838 VGND.n899 VGND.n898 9.3005
R1839 VGND.n897 VGND.n61 9.3005
R1840 VGND.n896 VGND.n895 9.3005
R1841 VGND.n894 VGND.n68 9.3005
R1842 VGND.n893 VGND.n892 9.3005
R1843 VGND.n938 VGND.n937 9.3005
R1844 VGND.n13 VGND.n11 9.3005
R1845 VGND.n882 VGND.n881 9.3005
R1846 VGND.n880 VGND.n115 9.3005
R1847 VGND.n879 VGND.n878 9.3005
R1848 VGND.n117 VGND.n116 9.3005
R1849 VGND.n860 VGND.n859 9.3005
R1850 VGND.n858 VGND.n131 9.3005
R1851 VGND.n857 VGND.n856 9.3005
R1852 VGND.n133 VGND.n132 9.3005
R1853 VGND.n834 VGND.n833 9.3005
R1854 VGND.n832 VGND.n145 9.3005
R1855 VGND.n831 VGND.n830 9.3005
R1856 VGND.n147 VGND.n146 9.3005
R1857 VGND.n814 VGND.n813 9.3005
R1858 VGND.n812 VGND.n159 9.3005
R1859 VGND.n811 VGND.n810 9.3005
R1860 VGND.n161 VGND.n160 9.3005
R1861 VGND.n798 VGND.n797 9.3005
R1862 VGND.n796 VGND.n173 9.3005
R1863 VGND.n795 VGND.n794 9.3005
R1864 VGND.n175 VGND.n174 9.3005
R1865 VGND.n778 VGND.n777 9.3005
R1866 VGND.n776 VGND.n187 9.3005
R1867 VGND.n775 VGND.n774 9.3005
R1868 VGND.n189 VGND.n188 9.3005
R1869 VGND.n762 VGND.n761 9.3005
R1870 VGND.n760 VGND.n201 9.3005
R1871 VGND.n759 VGND.n758 9.3005
R1872 VGND.n203 VGND.n202 9.3005
R1873 VGND.n746 VGND.n745 9.3005
R1874 VGND.n744 VGND.n218 9.3005
R1875 VGND.n743 VGND.n742 9.3005
R1876 VGND.n220 VGND.n219 9.3005
R1877 VGND.n729 VGND.n728 9.3005
R1878 VGND.n727 VGND.n232 9.3005
R1879 VGND.n726 VGND.n725 9.3005
R1880 VGND.n234 VGND.n233 9.3005
R1881 VGND.n713 VGND.n712 9.3005
R1882 VGND.n711 VGND.n249 9.3005
R1883 VGND.n710 VGND.n709 9.3005
R1884 VGND.n251 VGND.n250 9.3005
R1885 VGND.n696 VGND.n695 9.3005
R1886 VGND.n694 VGND.n263 9.3005
R1887 VGND.n693 VGND.n692 9.3005
R1888 VGND.n265 VGND.n264 9.3005
R1889 VGND.n680 VGND.n679 9.3005
R1890 VGND.n678 VGND.n280 9.3005
R1891 VGND.n677 VGND.n676 9.3005
R1892 VGND.n282 VGND.n281 9.3005
R1893 VGND.n663 VGND.n662 9.3005
R1894 VGND.n661 VGND.n294 9.3005
R1895 VGND.n660 VGND.n659 9.3005
R1896 VGND.n296 VGND.n295 9.3005
R1897 VGND.n637 VGND.n636 9.3005
R1898 VGND.n635 VGND.n308 9.3005
R1899 VGND.n634 VGND.n633 9.3005
R1900 VGND.n310 VGND.n309 9.3005
R1901 VGND.n619 VGND.n618 9.3005
R1902 VGND.n617 VGND.n322 9.3005
R1903 VGND.n616 VGND.n615 9.3005
R1904 VGND.n582 VGND.n581 9.3005
R1905 VGND.n437 VGND.n341 9.3005
R1906 VGND.n436 VGND.n435 9.3005
R1907 VGND.n344 VGND.n343 9.3005
R1908 VGND.n429 VGND.n428 9.3005
R1909 VGND.n427 VGND.n346 9.3005
R1910 VGND.n426 VGND.n425 9.3005
R1911 VGND.n348 VGND.n347 9.3005
R1912 VGND.n419 VGND.n418 9.3005
R1913 VGND.n417 VGND.n350 9.3005
R1914 VGND.n416 VGND.n415 9.3005
R1915 VGND.n352 VGND.n351 9.3005
R1916 VGND.n406 VGND.n353 9.3005
R1917 VGND.n408 VGND.n407 9.3005
R1918 VGND.n405 VGND.n355 9.3005
R1919 VGND.n404 VGND.n403 9.3005
R1920 VGND.n357 VGND.n356 9.3005
R1921 VGND.n394 VGND.n358 9.3005
R1922 VGND.n396 VGND.n395 9.3005
R1923 VGND.n393 VGND.n360 9.3005
R1924 VGND.n392 VGND.n391 9.3005
R1925 VGND.n362 VGND.n361 9.3005
R1926 VGND.n386 VGND.n385 9.3005
R1927 VGND.n384 VGND.n364 9.3005
R1928 VGND.n383 VGND.n382 9.3005
R1929 VGND.n366 VGND.n365 9.3005
R1930 VGND.n373 VGND.n368 9.3005
R1931 VGND.n375 VGND.n374 9.3005
R1932 VGND.n372 VGND.n371 9.3005
R1933 VGND.n324 VGND.n323 9.3005
R1934 VGND.n772 VGND.t8 7.74244
R1935 VGND.n756 VGND.t2 7.74244
R1936 VGND.n292 VGND.t9 7.74244
R1937 VGND.t3 VGND.n298 7.74244
R1938 VGND.n652 VGND.n651 4.56146
R1939 VGND.n848 VGND.n847 4.56146
R1940 VGND.n649 VGND.n647 4.5005
R1941 VGND.n845 VGND.n843 4.5005
R1942 VGND.n647 VGND.n646 2.89637
R1943 VGND.n843 VGND.n842 2.89637
R1944 VGND.n867 VGND.n866 2.72618
R1945 VGND.n823 VGND.n822 2.72618
R1946 VGND.n787 VGND.n786 2.72618
R1947 VGND.n211 VGND.n210 2.72618
R1948 VGND.n242 VGND.n241 2.72618
R1949 VGND.n273 VGND.n272 2.72618
R1950 VGND.n627 VGND.n626 2.71943
R1951 VGND.n849 VGND.n848 2.66587
R1952 VGND.n653 VGND.n652 2.6605
R1953 VGND.n937 VGND.n936 0.459739
R1954 VGND.n616 VGND.n323 0.459739
R1955 VGND.n893 VGND.n69 0.288543
R1956 VGND.n581 VGND.n580 0.288543
R1957 VGND.n646 VGND.n644 0.28419
R1958 VGND.n842 VGND.n840 0.28419
R1959 VGND.n580 VGND.n338 0.272239
R1960 VGND.n105 VGND.n69 0.272239
R1961 VGND.n649 VGND.n648 0.255162
R1962 VGND.n845 VGND.n844 0.255162
R1963 VGND.n608 VGND.n330 0.196152
R1964 VGND.n601 VGND.n330 0.196152
R1965 VGND.n601 VGND.n600 0.196152
R1966 VGND.n600 VGND.n599 0.196152
R1967 VGND.n599 VGND.n334 0.196152
R1968 VGND.n592 VGND.n334 0.196152
R1969 VGND.n592 VGND.n591 0.196152
R1970 VGND.n591 VGND.n590 0.196152
R1971 VGND.n590 VGND.n338 0.196152
R1972 VGND.n889 VGND.n888 0.196152
R1973 VGND.n888 VGND.n887 0.196152
R1974 VGND.n887 VGND.n108 0.196152
R1975 VGND.n495 VGND.n108 0.196152
R1976 VGND.n496 VGND.n495 0.196152
R1977 VGND.n497 VGND.n496 0.196152
R1978 VGND.n497 VGND.n490 0.196152
R1979 VGND.n501 VGND.n490 0.196152
R1980 VGND.n502 VGND.n501 0.196152
R1981 VGND.n503 VGND.n502 0.196152
R1982 VGND.n503 VGND.n486 0.196152
R1983 VGND.n507 VGND.n486 0.196152
R1984 VGND.n508 VGND.n507 0.196152
R1985 VGND.n509 VGND.n508 0.196152
R1986 VGND.n509 VGND.n482 0.196152
R1987 VGND.n513 VGND.n482 0.196152
R1988 VGND.n514 VGND.n513 0.196152
R1989 VGND.n515 VGND.n514 0.196152
R1990 VGND.n515 VGND.n478 0.196152
R1991 VGND.n519 VGND.n478 0.196152
R1992 VGND.n520 VGND.n519 0.196152
R1993 VGND.n521 VGND.n520 0.196152
R1994 VGND.n521 VGND.n474 0.196152
R1995 VGND.n525 VGND.n474 0.196152
R1996 VGND.n526 VGND.n525 0.196152
R1997 VGND.n527 VGND.n526 0.196152
R1998 VGND.n527 VGND.n470 0.196152
R1999 VGND.n531 VGND.n470 0.196152
R2000 VGND.n532 VGND.n531 0.196152
R2001 VGND.n533 VGND.n532 0.196152
R2002 VGND.n533 VGND.n466 0.196152
R2003 VGND.n537 VGND.n466 0.196152
R2004 VGND.n538 VGND.n537 0.196152
R2005 VGND.n539 VGND.n538 0.196152
R2006 VGND.n539 VGND.n462 0.196152
R2007 VGND.n543 VGND.n462 0.196152
R2008 VGND.n544 VGND.n543 0.196152
R2009 VGND.n545 VGND.n544 0.196152
R2010 VGND.n545 VGND.n458 0.196152
R2011 VGND.n549 VGND.n458 0.196152
R2012 VGND.n550 VGND.n549 0.196152
R2013 VGND.n551 VGND.n550 0.196152
R2014 VGND.n551 VGND.n454 0.196152
R2015 VGND.n555 VGND.n454 0.196152
R2016 VGND.n556 VGND.n555 0.196152
R2017 VGND.n557 VGND.n556 0.196152
R2018 VGND.n557 VGND.n450 0.196152
R2019 VGND.n561 VGND.n450 0.196152
R2020 VGND.n562 VGND.n561 0.196152
R2021 VGND.n563 VGND.n562 0.196152
R2022 VGND.n563 VGND.n446 0.196152
R2023 VGND.n567 VGND.n446 0.196152
R2024 VGND.n568 VGND.n567 0.196152
R2025 VGND.n569 VGND.n568 0.196152
R2026 VGND.n569 VGND.n442 0.196152
R2027 VGND.n573 VGND.n442 0.196152
R2028 VGND.n574 VGND.n573 0.196152
R2029 VGND.n575 VGND.n574 0.196152
R2030 VGND.n575 VGND.n438 0.196152
R2031 VGND.n579 VGND.n438 0.196152
R2032 VGND.n93 VGND.n0 0.196152
R2033 VGND.n93 VGND.n84 0.196152
R2034 VGND.n97 VGND.n84 0.196152
R2035 VGND.n98 VGND.n97 0.196152
R2036 VGND.n99 VGND.n98 0.196152
R2037 VGND.n99 VGND.n76 0.196152
R2038 VGND.n103 VGND.n76 0.196152
R2039 VGND.n104 VGND.n103 0.196152
R2040 VGND.n105 VGND.n104 0.196152
R2041 VGND.n894 VGND.n893 0.196152
R2042 VGND.n895 VGND.n894 0.196152
R2043 VGND.n895 VGND.n61 0.196152
R2044 VGND.n899 VGND.n61 0.196152
R2045 VGND.n900 VGND.n899 0.196152
R2046 VGND.n901 VGND.n900 0.196152
R2047 VGND.n901 VGND.n53 0.196152
R2048 VGND.n905 VGND.n53 0.196152
R2049 VGND.n906 VGND.n905 0.196152
R2050 VGND.n907 VGND.n906 0.196152
R2051 VGND.n907 VGND.n45 0.196152
R2052 VGND.n911 VGND.n45 0.196152
R2053 VGND.n912 VGND.n911 0.196152
R2054 VGND.n913 VGND.n912 0.196152
R2055 VGND.n913 VGND.n37 0.196152
R2056 VGND.n917 VGND.n37 0.196152
R2057 VGND.n918 VGND.n917 0.196152
R2058 VGND.n919 VGND.n918 0.196152
R2059 VGND.n919 VGND.n29 0.196152
R2060 VGND.n923 VGND.n29 0.196152
R2061 VGND.n924 VGND.n923 0.196152
R2062 VGND.n925 VGND.n924 0.196152
R2063 VGND.n925 VGND.n21 0.196152
R2064 VGND.n929 VGND.n21 0.196152
R2065 VGND.n930 VGND.n929 0.196152
R2066 VGND.n931 VGND.n930 0.196152
R2067 VGND.n931 VGND.n14 0.196152
R2068 VGND.n935 VGND.n14 0.196152
R2069 VGND.n936 VGND.n935 0.196152
R2070 VGND.n937 VGND.n13 0.196152
R2071 VGND.n881 VGND.n13 0.196152
R2072 VGND.n881 VGND.n880 0.196152
R2073 VGND.n880 VGND.n879 0.196152
R2074 VGND.n879 VGND.n116 0.196152
R2075 VGND.n859 VGND.n116 0.196152
R2076 VGND.n859 VGND.n858 0.196152
R2077 VGND.n858 VGND.n857 0.196152
R2078 VGND.n857 VGND.n132 0.196152
R2079 VGND.n833 VGND.n132 0.196152
R2080 VGND.n833 VGND.n832 0.196152
R2081 VGND.n832 VGND.n831 0.196152
R2082 VGND.n831 VGND.n146 0.196152
R2083 VGND.n813 VGND.n146 0.196152
R2084 VGND.n813 VGND.n812 0.196152
R2085 VGND.n812 VGND.n811 0.196152
R2086 VGND.n811 VGND.n160 0.196152
R2087 VGND.n797 VGND.n160 0.196152
R2088 VGND.n797 VGND.n796 0.196152
R2089 VGND.n796 VGND.n795 0.196152
R2090 VGND.n795 VGND.n174 0.196152
R2091 VGND.n777 VGND.n174 0.196152
R2092 VGND.n777 VGND.n776 0.196152
R2093 VGND.n776 VGND.n775 0.196152
R2094 VGND.n775 VGND.n188 0.196152
R2095 VGND.n761 VGND.n188 0.196152
R2096 VGND.n761 VGND.n760 0.196152
R2097 VGND.n760 VGND.n759 0.196152
R2098 VGND.n759 VGND.n202 0.196152
R2099 VGND.n745 VGND.n202 0.196152
R2100 VGND.n745 VGND.n744 0.196152
R2101 VGND.n744 VGND.n743 0.196152
R2102 VGND.n743 VGND.n219 0.196152
R2103 VGND.n728 VGND.n219 0.196152
R2104 VGND.n728 VGND.n727 0.196152
R2105 VGND.n727 VGND.n726 0.196152
R2106 VGND.n726 VGND.n233 0.196152
R2107 VGND.n712 VGND.n233 0.196152
R2108 VGND.n712 VGND.n711 0.196152
R2109 VGND.n711 VGND.n710 0.196152
R2110 VGND.n710 VGND.n250 0.196152
R2111 VGND.n695 VGND.n250 0.196152
R2112 VGND.n695 VGND.n694 0.196152
R2113 VGND.n694 VGND.n693 0.196152
R2114 VGND.n693 VGND.n264 0.196152
R2115 VGND.n679 VGND.n264 0.196152
R2116 VGND.n679 VGND.n678 0.196152
R2117 VGND.n678 VGND.n677 0.196152
R2118 VGND.n677 VGND.n281 0.196152
R2119 VGND.n662 VGND.n281 0.196152
R2120 VGND.n662 VGND.n661 0.196152
R2121 VGND.n661 VGND.n660 0.196152
R2122 VGND.n660 VGND.n295 0.196152
R2123 VGND.n636 VGND.n295 0.196152
R2124 VGND.n636 VGND.n635 0.196152
R2125 VGND.n635 VGND.n634 0.196152
R2126 VGND.n634 VGND.n309 0.196152
R2127 VGND.n618 VGND.n309 0.196152
R2128 VGND.n618 VGND.n617 0.196152
R2129 VGND.n617 VGND.n616 0.196152
R2130 VGND.n581 VGND.n437 0.196152
R2131 VGND.n437 VGND.n436 0.196152
R2132 VGND.n436 VGND.n343 0.196152
R2133 VGND.n428 VGND.n343 0.196152
R2134 VGND.n428 VGND.n427 0.196152
R2135 VGND.n427 VGND.n426 0.196152
R2136 VGND.n426 VGND.n347 0.196152
R2137 VGND.n418 VGND.n347 0.196152
R2138 VGND.n418 VGND.n417 0.196152
R2139 VGND.n417 VGND.n416 0.196152
R2140 VGND.n416 VGND.n351 0.196152
R2141 VGND.n406 VGND.n351 0.196152
R2142 VGND.n407 VGND.n406 0.196152
R2143 VGND.n407 VGND.n405 0.196152
R2144 VGND.n405 VGND.n404 0.196152
R2145 VGND.n404 VGND.n356 0.196152
R2146 VGND.n394 VGND.n356 0.196152
R2147 VGND.n395 VGND.n394 0.196152
R2148 VGND.n395 VGND.n393 0.196152
R2149 VGND.n393 VGND.n392 0.196152
R2150 VGND.n392 VGND.n361 0.196152
R2151 VGND.n385 VGND.n361 0.196152
R2152 VGND.n385 VGND.n384 0.196152
R2153 VGND.n384 VGND.n383 0.196152
R2154 VGND.n383 VGND.n365 0.196152
R2155 VGND.n373 VGND.n365 0.196152
R2156 VGND.n374 VGND.n373 0.196152
R2157 VGND.n374 VGND.n372 0.196152
R2158 VGND.n372 VGND.n323 0.196152
R2159 VGND.n889 VGND.n69 0.171696
R2160 VGND.n580 VGND.n579 0.171696
R2161 VGND.n652 VGND.n647 0.121712
R2162 VGND.n848 VGND.n843 0.121712
R2163 VGND.n609 VGND.n608 0.117348
R2164 VGND.n944 VGND.n0 0.117348
R2165 VGND.n651 VGND.n649 0.0614182
R2166 VGND.n847 VGND.n845 0.0614182
R2167 VGND.n869 VGND.n1 0.0455
R2168 VGND.n871 VGND.n869 0.0455
R2169 VGND.n872 VGND.n871 0.0455
R2170 VGND.n873 VGND.n872 0.0455
R2171 VGND.n873 VGND.n868 0.0455
R2172 VGND.n865 VGND.n125 0.0455
R2173 VGND.n851 VGND.n125 0.0455
R2174 VGND.n851 VGND.n850 0.0455
R2175 VGND.n839 VGND.n139 0.0455
R2176 VGND.n825 VGND.n139 0.0455
R2177 VGND.n825 VGND.n824 0.0455
R2178 VGND.n819 VGND.n153 0.0455
R2179 VGND.n805 VGND.n153 0.0455
R2180 VGND.n805 VGND.n804 0.0455
R2181 VGND.n804 VGND.n803 0.0455
R2182 VGND.n803 VGND.n167 0.0455
R2183 VGND.n789 VGND.n167 0.0455
R2184 VGND.n789 VGND.n788 0.0455
R2185 VGND.n783 VGND.n181 0.0455
R2186 VGND.n769 VGND.n181 0.0455
R2187 VGND.n769 VGND.n768 0.0455
R2188 VGND.n768 VGND.n767 0.0455
R2189 VGND.n767 VGND.n195 0.0455
R2190 VGND.n753 VGND.n195 0.0455
R2191 VGND.n753 VGND.n752 0.0455
R2192 VGND.n752 VGND.n751 0.0455
R2193 VGND.n737 VGND.n736 0.0455
R2194 VGND.n737 VGND.n735 0.0455
R2195 VGND.n735 VGND.n734 0.0455
R2196 VGND.n734 VGND.n225 0.0455
R2197 VGND.n720 VGND.n225 0.0455
R2198 VGND.n720 VGND.n719 0.0455
R2199 VGND.n719 VGND.n718 0.0455
R2200 VGND.n704 VGND.n703 0.0455
R2201 VGND.n704 VGND.n702 0.0455
R2202 VGND.n702 VGND.n701 0.0455
R2203 VGND.n701 VGND.n256 0.0455
R2204 VGND.n687 VGND.n256 0.0455
R2205 VGND.n687 VGND.n686 0.0455
R2206 VGND.n686 VGND.n685 0.0455
R2207 VGND.n671 VGND.n670 0.0455
R2208 VGND.n671 VGND.n669 0.0455
R2209 VGND.n669 VGND.n668 0.0455
R2210 VGND.n668 VGND.n287 0.0455
R2211 VGND.n654 VGND.n643 0.0455
R2212 VGND.n643 VGND.n642 0.0455
R2213 VGND.n642 VGND.n302 0.0455
R2214 VGND.n628 VGND.n625 0.0455
R2215 VGND.n625 VGND.n624 0.0455
R2216 VGND.n624 VGND.n316 0.0455
R2217 VGND.n610 VGND.n316 0.0455
R2218 VGND.n654 VGND.n653 0.044875
R2219 VGND.n944 VGND.n1 0.039875
R2220 VGND.n610 VGND.n609 0.039875
R2221 VGND.n867 VGND.n865 0.038
R2222 VGND.n685 VGND.n273 0.038
R2223 VGND.n788 VGND.n787 0.037375
R2224 VGND.n736 VGND.n211 0.03675
R2225 VGND.n628 VGND.n627 0.03675
R2226 VGND VGND.n944 0.0305
R2227 VGND.n849 VGND.n839 0.029875
R2228 VGND.n703 VGND.n242 0.024875
R2229 VGND.n824 VGND.n823 0.02425
R2230 VGND.n823 VGND.n819 0.02175
R2231 VGND.n718 VGND.n242 0.021125
R2232 VGND.n850 VGND.n849 0.016125
R2233 VGND.n751 VGND.n211 0.00925
R2234 VGND.n627 VGND.n302 0.00925
R2235 VGND.n787 VGND.n783 0.008625
R2236 VGND.n868 VGND.n867 0.008
R2237 VGND.n670 VGND.n273 0.008
R2238 VGND.n653 VGND.n287 0.001125
R2239 a_433_1469.n227 a_433_1469.n226 184.74
R2240 a_433_1469.n233 a_433_1469.n232 184.74
R2241 a_433_1469.n239 a_433_1469.n238 184.74
R2242 a_433_1469.n245 a_433_1469.n244 184.74
R2243 a_433_1469.n250 a_433_1469.n249 184.74
R2244 a_433_1469.n256 a_433_1469.n255 184.74
R2245 a_433_1469.n261 a_433_1469.n260 184.74
R2246 a_433_1469.n267 a_433_1469.n266 184.74
R2247 a_433_1469.n272 a_433_1469.n271 184.74
R2248 a_433_1469.n278 a_433_1469.n277 184.74
R2249 a_433_1469.n284 a_433_1469.n283 184.74
R2250 a_433_1469.n82 a_433_1469.n81 184.74
R2251 a_433_1469.n87 a_433_1469.n86 184.74
R2252 a_433_1469.n93 a_433_1469.n92 184.74
R2253 a_433_1469.n98 a_433_1469.n97 184.74
R2254 a_433_1469.n104 a_433_1469.n103 184.74
R2255 a_433_1469.n144 a_433_1469.n108 184.74
R2256 a_433_1469.n138 a_433_1469.n111 184.74
R2257 a_433_1469.n133 a_433_1469.n113 184.74
R2258 a_433_1469.n127 a_433_1469.n116 184.74
R2259 a_433_1469.n122 a_433_1469.n118 184.74
R2260 a_433_1469.n217 a_433_1469.t71 129.379
R2261 a_433_1469.n44 a_433_1469.t61 129.377
R2262 a_433_1469.n216 a_433_1469.t83 129.376
R2263 a_433_1469.n218 a_433_1469.t59 129.376
R2264 a_433_1469.n46 a_433_1469.t86 129.376
R2265 a_433_1469.n45 a_433_1469.t73 129.376
R2266 a_433_1469.n43 a_433_1469.t26 129.376
R2267 a_433_1469.n223 a_433_1469.t119 116.188
R2268 a_433_1469.n40 a_433_1469.n38 102.721
R2269 a_433_1469.n162 a_433_1469.n41 102.52
R2270 a_433_1469.n164 a_433_1469.n163 102.326
R2271 a_433_1469.n40 a_433_1469.n39 102.325
R2272 a_433_1469.n187 a_433_1469.n186 99.3783
R2273 a_433_1469.n59 a_433_1469.n58 99.3783
R2274 a_433_1469.n171 a_433_1469.n170 99.3783
R2275 a_433_1469.n156 a_433_1469.n155 99.3783
R2276 a_433_1469.n173 a_433_1469.n172 99.3768
R2277 a_433_1469.n311 a_433_1469.n310 99.3764
R2278 a_433_1469.n214 a_433_1469.n213 99.3764
R2279 a_433_1469.n185 a_433_1469.n184 99.3764
R2280 a_433_1469.n189 a_433_1469.n188 99.3764
R2281 a_433_1469.n57 a_433_1469.n56 99.3764
R2282 a_433_1469.n61 a_433_1469.n60 99.3764
R2283 a_433_1469.n175 a_433_1469.n174 99.3764
R2284 a_433_1469.n169 a_433_1469.n168 99.3764
R2285 a_433_1469.n160 a_433_1469.n159 99.3764
R2286 a_433_1469.n158 a_433_1469.n157 99.3764
R2287 a_433_1469.n154 a_433_1469.n153 99.3764
R2288 a_433_1469.n37 a_433_1469.n36 99.3764
R2289 a_433_1469.n242 a_433_1469.n22 97.4694
R2290 a_433_1469.n253 a_433_1469.n17 97.4694
R2291 a_433_1469.n264 a_433_1469.n12 97.4694
R2292 a_433_1469.n275 a_433_1469.n7 97.4694
R2293 a_433_1469.n90 a_433_1469.n75 97.4622
R2294 a_433_1469.n101 a_433_1469.n70 97.4622
R2295 a_433_1469.n140 a_433_1469.n109 97.4622
R2296 a_433_1469.n129 a_433_1469.n114 97.4622
R2297 a_433_1469.n64 a_433_1469.n63 97.1514
R2298 a_433_1469.n66 a_433_1469.n65 97.1031
R2299 a_433_1469.n193 a_433_1469.n192 86.1871
R2300 a_433_1469.n201 a_433_1469.n200 86.1871
R2301 a_433_1469.n209 a_433_1469.n208 86.1871
R2302 a_433_1469.n180 a_433_1469.n179 86.1871
R2303 a_433_1469.n52 a_433_1469.n51 86.1871
R2304 a_433_1469.n290 a_433_1469.n289 86.1871
R2305 a_433_1469.n148 a_433_1469.n147 86.1871
R2306 a_433_1469.n298 a_433_1469.n297 86.1871
R2307 a_433_1469.n306 a_433_1469.n305 86.1871
R2308 a_433_1469.n80 a_433_1469.t57 85.142
R2309 a_433_1469.n119 a_433_1469.t24 85.142
R2310 a_433_1469.n303 a_433_1469.t60 84.9605
R2311 a_433_1469.n198 a_433_1469.t78 84.9556
R2312 a_433_1469.n206 a_433_1469.t66 84.9556
R2313 a_433_1469.n287 a_433_1469.t84 84.9556
R2314 a_433_1469.n295 a_433_1469.t72 84.9556
R2315 a_433_1469.n198 a_433_1469.t81 84.9545
R2316 a_433_1469.n206 a_433_1469.t69 84.9545
R2317 a_433_1469.n295 a_433_1469.t75 84.9545
R2318 a_433_1469.n303 a_433_1469.t63 84.9497
R2319 a_433_1469.n228 a_433_1469.n227 77.1778
R2320 a_433_1469.n234 a_433_1469.n233 77.1778
R2321 a_433_1469.n240 a_433_1469.n239 77.1778
R2322 a_433_1469.n246 a_433_1469.n245 77.1778
R2323 a_433_1469.n251 a_433_1469.n250 77.1778
R2324 a_433_1469.n257 a_433_1469.n256 77.1778
R2325 a_433_1469.n262 a_433_1469.n261 77.1778
R2326 a_433_1469.n268 a_433_1469.n267 77.1778
R2327 a_433_1469.n273 a_433_1469.n272 77.1778
R2328 a_433_1469.n279 a_433_1469.n278 77.1778
R2329 a_433_1469.n285 a_433_1469.n284 77.1778
R2330 a_433_1469.n83 a_433_1469.n82 77.1778
R2331 a_433_1469.n88 a_433_1469.n87 77.1778
R2332 a_433_1469.n94 a_433_1469.n93 77.1778
R2333 a_433_1469.n99 a_433_1469.n98 77.1778
R2334 a_433_1469.n105 a_433_1469.n104 77.1778
R2335 a_433_1469.n142 a_433_1469.n108 77.1778
R2336 a_433_1469.n136 a_433_1469.n111 77.1778
R2337 a_433_1469.n131 a_433_1469.n113 77.1778
R2338 a_433_1469.n125 a_433_1469.n116 77.1778
R2339 a_433_1469.n120 a_433_1469.n118 77.1778
R2340 a_433_1469.n311 a_433_1469.t25 30.0005
R2341 a_433_1469.t28 a_433_1469.n311 30.0005
R2342 a_433_1469.n192 a_433_1469.t115 30.0005
R2343 a_433_1469.n192 a_433_1469.t118 30.0005
R2344 a_433_1469.n200 a_433_1469.t79 30.0005
R2345 a_433_1469.n200 a_433_1469.t82 30.0005
R2346 a_433_1469.n208 a_433_1469.t67 30.0005
R2347 a_433_1469.n208 a_433_1469.t70 30.0005
R2348 a_433_1469.n213 a_433_1469.t55 30.0005
R2349 a_433_1469.n213 a_433_1469.t58 30.0005
R2350 a_433_1469.n179 a_433_1469.t112 30.0005
R2351 a_433_1469.n179 a_433_1469.t116 30.0005
R2352 a_433_1469.n184 a_433_1469.t15 30.0005
R2353 a_433_1469.n184 a_433_1469.t80 30.0005
R2354 a_433_1469.n186 a_433_1469.t23 30.0005
R2355 a_433_1469.n186 a_433_1469.t68 30.0005
R2356 a_433_1469.n188 a_433_1469.t52 30.0005
R2357 a_433_1469.n188 a_433_1469.t56 30.0005
R2358 a_433_1469.n22 a_433_1469.t109 30.0005
R2359 a_433_1469.n22 a_433_1469.t113 30.0005
R2360 a_433_1469.n17 a_433_1469.t103 30.0005
R2361 a_433_1469.n17 a_433_1469.t106 30.0005
R2362 a_433_1469.n12 a_433_1469.t97 30.0005
R2363 a_433_1469.n12 a_433_1469.t100 30.0005
R2364 a_433_1469.n7 a_433_1469.t91 30.0005
R2365 a_433_1469.n7 a_433_1469.t94 30.0005
R2366 a_433_1469.n51 a_433_1469.t88 30.0005
R2367 a_433_1469.n51 a_433_1469.t92 30.0005
R2368 a_433_1469.n56 a_433_1469.t76 30.0005
R2369 a_433_1469.n56 a_433_1469.t8 30.0005
R2370 a_433_1469.n58 a_433_1469.t64 30.0005
R2371 a_433_1469.n58 a_433_1469.t16 30.0005
R2372 a_433_1469.n60 a_433_1469.t29 30.0005
R2373 a_433_1469.n60 a_433_1469.t31 30.0005
R2374 a_433_1469.n289 a_433_1469.t85 30.0005
R2375 a_433_1469.n289 a_433_1469.t89 30.0005
R2376 a_433_1469.n174 a_433_1469.t107 30.0005
R2377 a_433_1469.n174 a_433_1469.t110 30.0005
R2378 a_433_1469.n172 a_433_1469.t13 30.0005
R2379 a_433_1469.n172 a_433_1469.t14 30.0005
R2380 a_433_1469.n170 a_433_1469.t21 30.0005
R2381 a_433_1469.n170 a_433_1469.t22 30.0005
R2382 a_433_1469.n168 a_433_1469.t46 30.0005
R2383 a_433_1469.n168 a_433_1469.t49 30.0005
R2384 a_433_1469.n63 a_433_1469.t11 30.0005
R2385 a_433_1469.n63 a_433_1469.t12 30.0005
R2386 a_433_1469.n38 a_433_1469.t6 30.0005
R2387 a_433_1469.n38 a_433_1469.t7 30.0005
R2388 a_433_1469.n39 a_433_1469.t4 30.0005
R2389 a_433_1469.n39 a_433_1469.t5 30.0005
R2390 a_433_1469.n163 a_433_1469.t2 30.0005
R2391 a_433_1469.n163 a_433_1469.t3 30.0005
R2392 a_433_1469.n41 a_433_1469.t0 30.0005
R2393 a_433_1469.n41 a_433_1469.t1 30.0005
R2394 a_433_1469.n159 a_433_1469.t95 30.0005
R2395 a_433_1469.n159 a_433_1469.t98 30.0005
R2396 a_433_1469.n157 a_433_1469.t9 30.0005
R2397 a_433_1469.n157 a_433_1469.t10 30.0005
R2398 a_433_1469.n155 a_433_1469.t17 30.0005
R2399 a_433_1469.n155 a_433_1469.t18 30.0005
R2400 a_433_1469.n153 a_433_1469.t34 30.0005
R2401 a_433_1469.n153 a_433_1469.t37 30.0005
R2402 a_433_1469.n36 a_433_1469.t101 30.0005
R2403 a_433_1469.n36 a_433_1469.t104 30.0005
R2404 a_433_1469.n65 a_433_1469.t19 30.0005
R2405 a_433_1469.n65 a_433_1469.t20 30.0005
R2406 a_433_1469.n75 a_433_1469.t50 30.0005
R2407 a_433_1469.n75 a_433_1469.t53 30.0005
R2408 a_433_1469.n70 a_433_1469.t43 30.0005
R2409 a_433_1469.n70 a_433_1469.t47 30.0005
R2410 a_433_1469.n109 a_433_1469.t38 30.0005
R2411 a_433_1469.n109 a_433_1469.t40 30.0005
R2412 a_433_1469.n114 a_433_1469.t32 30.0005
R2413 a_433_1469.n114 a_433_1469.t35 30.0005
R2414 a_433_1469.n147 a_433_1469.t41 30.0005
R2415 a_433_1469.n147 a_433_1469.t44 30.0005
R2416 a_433_1469.n297 a_433_1469.t74 30.0005
R2417 a_433_1469.n297 a_433_1469.t77 30.0005
R2418 a_433_1469.n305 a_433_1469.t62 30.0005
R2419 a_433_1469.n305 a_433_1469.t65 30.0005
R2420 a_433_1469.n226 a_433_1469.n30 27.1064
R2421 a_433_1469.n232 a_433_1469.n27 27.1064
R2422 a_433_1469.n238 a_433_1469.n24 27.1064
R2423 a_433_1469.n244 a_433_1469.n21 27.1064
R2424 a_433_1469.n249 a_433_1469.n19 27.1064
R2425 a_433_1469.n255 a_433_1469.n16 27.1064
R2426 a_433_1469.n260 a_433_1469.n14 27.1064
R2427 a_433_1469.n266 a_433_1469.n11 27.1064
R2428 a_433_1469.n271 a_433_1469.n9 27.1064
R2429 a_433_1469.n277 a_433_1469.n6 27.1064
R2430 a_433_1469.n283 a_433_1469.n3 27.1064
R2431 a_433_1469.n81 a_433_1469.n79 27.1064
R2432 a_433_1469.n86 a_433_1469.n77 27.1064
R2433 a_433_1469.n92 a_433_1469.n74 27.1064
R2434 a_433_1469.n97 a_433_1469.n72 27.1064
R2435 a_433_1469.n103 a_433_1469.n69 27.1064
R2436 a_433_1469.n144 a_433_1469.n143 27.1064
R2437 a_433_1469.n138 a_433_1469.n137 27.1064
R2438 a_433_1469.n133 a_433_1469.n132 27.1064
R2439 a_433_1469.n127 a_433_1469.n126 27.1064
R2440 a_433_1469.n122 a_433_1469.n121 27.1064
R2441 a_433_1469.n227 a_433_1469.t117 24.1005
R2442 a_433_1469.n233 a_433_1469.t114 24.1005
R2443 a_433_1469.n239 a_433_1469.t111 24.1005
R2444 a_433_1469.n245 a_433_1469.t108 24.1005
R2445 a_433_1469.n250 a_433_1469.t105 24.1005
R2446 a_433_1469.n256 a_433_1469.t102 24.1005
R2447 a_433_1469.n261 a_433_1469.t99 24.1005
R2448 a_433_1469.n267 a_433_1469.t96 24.1005
R2449 a_433_1469.n272 a_433_1469.t93 24.1005
R2450 a_433_1469.n278 a_433_1469.t90 24.1005
R2451 a_433_1469.n284 a_433_1469.t87 24.1005
R2452 a_433_1469.n82 a_433_1469.t54 24.1005
R2453 a_433_1469.n87 a_433_1469.t51 24.1005
R2454 a_433_1469.n93 a_433_1469.t48 24.1005
R2455 a_433_1469.n98 a_433_1469.t45 24.1005
R2456 a_433_1469.n104 a_433_1469.t42 24.1005
R2457 a_433_1469.n108 a_433_1469.t39 24.1005
R2458 a_433_1469.n111 a_433_1469.t36 24.1005
R2459 a_433_1469.n113 a_433_1469.t33 24.1005
R2460 a_433_1469.n116 a_433_1469.t30 24.1005
R2461 a_433_1469.n118 a_433_1469.t27 24.1005
R2462 a_433_1469.n229 a_433_1469.n228 23.0638
R2463 a_433_1469.n235 a_433_1469.n234 23.0638
R2464 a_433_1469.n241 a_433_1469.n240 23.0638
R2465 a_433_1469.n247 a_433_1469.n246 23.0638
R2466 a_433_1469.n252 a_433_1469.n251 23.0638
R2467 a_433_1469.n258 a_433_1469.n257 23.0638
R2468 a_433_1469.n263 a_433_1469.n262 23.0638
R2469 a_433_1469.n269 a_433_1469.n268 23.0638
R2470 a_433_1469.n274 a_433_1469.n273 23.0638
R2471 a_433_1469.n280 a_433_1469.n279 23.0638
R2472 a_433_1469.n286 a_433_1469.n285 23.0638
R2473 a_433_1469.n84 a_433_1469.n83 23.0638
R2474 a_433_1469.n89 a_433_1469.n88 23.0638
R2475 a_433_1469.n95 a_433_1469.n94 23.0638
R2476 a_433_1469.n100 a_433_1469.n99 23.0638
R2477 a_433_1469.n106 a_433_1469.n105 23.0638
R2478 a_433_1469.n142 a_433_1469.n141 23.0638
R2479 a_433_1469.n136 a_433_1469.n135 23.0638
R2480 a_433_1469.n131 a_433_1469.n130 23.0638
R2481 a_433_1469.n125 a_433_1469.n124 23.0638
R2482 a_433_1469.n120 a_433_1469.n119 23.0638
R2483 a_433_1469.n194 a_433_1469.n193 21.9364
R2484 a_433_1469.n202 a_433_1469.n201 21.9364
R2485 a_433_1469.n181 a_433_1469.n180 21.9364
R2486 a_433_1469.n53 a_433_1469.n52 21.9364
R2487 a_433_1469.n291 a_433_1469.n290 21.9364
R2488 a_433_1469.n223 a_433_1469.n222 21.9364
R2489 a_433_1469.n299 a_433_1469.n298 21.9364
R2490 a_433_1469.n193 a_433_1469.n28 21.9288
R2491 a_433_1469.n201 a_433_1469.n199 21.9288
R2492 a_433_1469.n209 a_433_1469.n207 21.9288
R2493 a_433_1469.n210 a_433_1469.n209 21.9288
R2494 a_433_1469.n180 a_433_1469.n25 21.9288
R2495 a_433_1469.n52 a_433_1469.n4 21.9288
R2496 a_433_1469.n290 a_433_1469.n288 21.9288
R2497 a_433_1469.n224 a_433_1469.n223 21.9288
R2498 a_433_1469.n149 a_433_1469.n148 21.9288
R2499 a_433_1469.n148 a_433_1469.n67 21.9288
R2500 a_433_1469.n298 a_433_1469.n296 21.9288
R2501 a_433_1469.n306 a_433_1469.n304 21.9288
R2502 a_433_1469.n307 a_433_1469.n306 21.9288
R2503 a_433_1469.n228 a_433_1469.n30 11.3247
R2504 a_433_1469.n234 a_433_1469.n27 11.3247
R2505 a_433_1469.n240 a_433_1469.n24 11.3247
R2506 a_433_1469.n246 a_433_1469.n21 11.3247
R2507 a_433_1469.n251 a_433_1469.n19 11.3247
R2508 a_433_1469.n257 a_433_1469.n16 11.3247
R2509 a_433_1469.n262 a_433_1469.n14 11.3247
R2510 a_433_1469.n268 a_433_1469.n11 11.3247
R2511 a_433_1469.n273 a_433_1469.n9 11.3247
R2512 a_433_1469.n279 a_433_1469.n6 11.3247
R2513 a_433_1469.n285 a_433_1469.n3 11.3247
R2514 a_433_1469.n83 a_433_1469.n79 11.3247
R2515 a_433_1469.n88 a_433_1469.n77 11.3247
R2516 a_433_1469.n94 a_433_1469.n74 11.3247
R2517 a_433_1469.n99 a_433_1469.n72 11.3247
R2518 a_433_1469.n105 a_433_1469.n69 11.3247
R2519 a_433_1469.n143 a_433_1469.n142 11.3247
R2520 a_433_1469.n137 a_433_1469.n136 11.3247
R2521 a_433_1469.n132 a_433_1469.n131 11.3247
R2522 a_433_1469.n126 a_433_1469.n125 11.3247
R2523 a_433_1469.n121 a_433_1469.n120 11.3247
R2524 a_433_1469.n283 a_433_1469.n282 9.3005
R2525 a_433_1469.n3 a_433_1469.n2 9.3005
R2526 a_433_1469.n277 a_433_1469.n276 9.3005
R2527 a_433_1469.n6 a_433_1469.n5 9.3005
R2528 a_433_1469.n271 a_433_1469.n270 9.3005
R2529 a_433_1469.n9 a_433_1469.n8 9.3005
R2530 a_433_1469.n266 a_433_1469.n265 9.3005
R2531 a_433_1469.n11 a_433_1469.n10 9.3005
R2532 a_433_1469.n260 a_433_1469.n259 9.3005
R2533 a_433_1469.n14 a_433_1469.n13 9.3005
R2534 a_433_1469.n255 a_433_1469.n254 9.3005
R2535 a_433_1469.n16 a_433_1469.n15 9.3005
R2536 a_433_1469.n249 a_433_1469.n248 9.3005
R2537 a_433_1469.n19 a_433_1469.n18 9.3005
R2538 a_433_1469.n244 a_433_1469.n243 9.3005
R2539 a_433_1469.n21 a_433_1469.n20 9.3005
R2540 a_433_1469.n238 a_433_1469.n237 9.3005
R2541 a_433_1469.n24 a_433_1469.n23 9.3005
R2542 a_433_1469.n232 a_433_1469.n231 9.3005
R2543 a_433_1469.n27 a_433_1469.n26 9.3005
R2544 a_433_1469.n226 a_433_1469.n225 9.3005
R2545 a_433_1469.n30 a_433_1469.n29 9.3005
R2546 a_433_1469.n123 a_433_1469.n122 9.3005
R2547 a_433_1469.n121 a_433_1469.n117 9.3005
R2548 a_433_1469.n128 a_433_1469.n127 9.3005
R2549 a_433_1469.n126 a_433_1469.n115 9.3005
R2550 a_433_1469.n134 a_433_1469.n133 9.3005
R2551 a_433_1469.n132 a_433_1469.n112 9.3005
R2552 a_433_1469.n139 a_433_1469.n138 9.3005
R2553 a_433_1469.n137 a_433_1469.n110 9.3005
R2554 a_433_1469.n145 a_433_1469.n144 9.3005
R2555 a_433_1469.n143 a_433_1469.n107 9.3005
R2556 a_433_1469.n103 a_433_1469.n102 9.3005
R2557 a_433_1469.n69 a_433_1469.n68 9.3005
R2558 a_433_1469.n97 a_433_1469.n96 9.3005
R2559 a_433_1469.n72 a_433_1469.n71 9.3005
R2560 a_433_1469.n92 a_433_1469.n91 9.3005
R2561 a_433_1469.n74 a_433_1469.n73 9.3005
R2562 a_433_1469.n86 a_433_1469.n85 9.3005
R2563 a_433_1469.n77 a_433_1469.n76 9.3005
R2564 a_433_1469.n81 a_433_1469.n80 9.3005
R2565 a_433_1469.n79 a_433_1469.n78 9.3005
R2566 a_433_1469.n47 a_433_1469.n42 9.20923
R2567 a_433_1469.n220 a_433_1469.n219 9.1144
R2568 a_433_1469.n151 a_433_1469.n150 5.25762
R2569 a_433_1469.n210 a_433_1469.n205 4.50429
R2570 a_433_1469.n307 a_433_1469.n302 4.50429
R2571 a_433_1469.n309 a_433_1469.n308 4.5005
R2572 a_433_1469.n299 a_433_1469.n294 4.5005
R2573 a_433_1469.n301 a_433_1469.n300 4.5005
R2574 a_433_1469.n291 a_433_1469.n1 4.5005
R2575 a_433_1469.n293 a_433_1469.n292 4.5005
R2576 a_433_1469.n222 a_433_1469.n221 4.5005
R2577 a_433_1469.n32 a_433_1469.n31 4.5005
R2578 a_433_1469.n194 a_433_1469.n191 4.5005
R2579 a_433_1469.n196 a_433_1469.n195 4.5005
R2580 a_433_1469.n212 a_433_1469.n211 4.5005
R2581 a_433_1469.n202 a_433_1469.n197 4.5005
R2582 a_433_1469.n204 a_433_1469.n203 4.5005
R2583 a_433_1469.n181 a_433_1469.n178 4.5005
R2584 a_433_1469.n183 a_433_1469.n182 4.5005
R2585 a_433_1469.n53 a_433_1469.n50 4.5005
R2586 a_433_1469.n55 a_433_1469.n54 4.5005
R2587 a_433_1469.n219 a_433_1469.n218 3.06955
R2588 a_433_1469.n310 a_433_1469.n0 3.06895
R2589 a_433_1469.n43 a_433_1469.n42 3.06895
R2590 a_433_1469.n62 a_433_1469.n61 3.06895
R2591 a_433_1469.n154 a_433_1469.n152 3.06895
R2592 a_433_1469.n169 a_433_1469.n34 3.06895
R2593 a_433_1469.n190 a_433_1469.n189 3.06895
R2594 a_433_1469.n215 a_433_1469.n214 3.06895
R2595 a_433_1469.n64 a_433_1469.n37 2.95979
R2596 a_433_1469.n176 a_433_1469.n175 2.94196
R2597 a_433_1469.n47 a_433_1469.n46 2.94136
R2598 a_433_1469.n50 a_433_1469.n49 2.88225
R2599 a_433_1469.n48 a_433_1469.n1 2.88105
R2600 a_433_1469.n221 a_433_1469.n220 2.88045
R2601 a_433_1469.n191 a_433_1469.n33 2.87985
R2602 a_433_1469.n178 a_433_1469.n177 2.87985
R2603 a_433_1469.n167 a_433_1469.n166 2.21678
R2604 a_433_1469.n161 a_433_1469.n35 2.21439
R2605 a_433_1469.n162 a_433_1469.n161 1.99111
R2606 a_433_1469.n166 a_433_1469.n165 1.99111
R2607 a_433_1469.n49 a_433_1469.n35 1.45793
R2608 a_433_1469.n167 a_433_1469.n35 1.45076
R2609 a_433_1469.n151 a_433_1469.n34 1.44603
R2610 a_433_1469.n152 a_433_1469.n151 1.43882
R2611 a_433_1469.n152 a_433_1469.n62 1.43641
R2612 a_433_1469.n190 a_433_1469.n34 1.43641
R2613 a_433_1469.n176 a_433_1469.n167 1.43407
R2614 a_433_1469.n177 a_433_1469.n176 1.42926
R2615 a_433_1469.n66 a_433_1469.n64 1.04418
R2616 a_433_1469.n67 a_433_1469.n66 0.997542
R2617 a_433_1469.n218 a_433_1469.n217 0.747992
R2618 a_433_1469.n189 a_433_1469.n187 0.747992
R2619 a_433_1469.n61 a_433_1469.n59 0.747992
R2620 a_433_1469.n171 a_433_1469.n169 0.747992
R2621 a_433_1469.n156 a_433_1469.n154 0.747992
R2622 a_433_1469.n44 a_433_1469.n43 0.74611
R2623 a_433_1469.n45 a_433_1469.n44 0.734771
R2624 a_433_1469.n160 a_433_1469.n158 0.734759
R2625 a_433_1469.n46 a_433_1469.n45 0.734759
R2626 a_433_1469.n217 a_433_1469.n216 0.73289
R2627 a_433_1469.n187 a_433_1469.n185 0.73289
R2628 a_433_1469.n59 a_433_1469.n57 0.73289
R2629 a_433_1469.n158 a_433_1469.n156 0.73289
R2630 a_433_1469.n175 a_433_1469.n173 0.732804
R2631 a_433_1469.n173 a_433_1469.n171 0.730934
R2632 a_433_1469.n166 a_433_1469.n37 0.727478
R2633 a_433_1469.n161 a_433_1469.n160 0.727478
R2634 a_433_1469.n62 a_433_1469.n0 0.724876
R2635 a_433_1469.n48 a_433_1469.n47 0.72007
R2636 a_433_1469.n177 a_433_1469.n33 0.720068
R2637 a_433_1469.n42 a_433_1469.n0 0.720068
R2638 a_433_1469.n215 a_433_1469.n190 0.720068
R2639 a_433_1469.n49 a_433_1469.n48 0.717707
R2640 a_433_1469.n220 a_433_1469.n33 0.717685
R2641 a_433_1469.n219 a_433_1469.n215 0.717685
R2642 a_433_1469.n310 a_433_1469.n309 0.687705
R2643 a_433_1469.n214 a_433_1469.n212 0.687705
R2644 a_433_1469.n216 a_433_1469.n32 0.674448
R2645 a_433_1469.n185 a_433_1469.n183 0.674448
R2646 a_433_1469.n57 a_433_1469.n55 0.674448
R2647 a_433_1469.n294 a_433_1469.n293 0.614136
R2648 a_433_1469.n197 a_433_1469.n196 0.614136
R2649 a_433_1469.n302 a_433_1469.n301 0.612242
R2650 a_433_1469.n205 a_433_1469.n204 0.612242
R2651 a_433_1469.n225 a_433_1469.n224 0.447105
R2652 a_433_1469.n270 a_433_1469.n269 0.3755
R2653 a_433_1469.n259 a_433_1469.n258 0.3755
R2654 a_433_1469.n248 a_433_1469.n247 0.3755
R2655 a_433_1469.n124 a_433_1469.n123 0.3755
R2656 a_433_1469.n135 a_433_1469.n134 0.3755
R2657 a_433_1469.n96 a_433_1469.n95 0.3755
R2658 a_433_1469.n85 a_433_1469.n84 0.3755
R2659 a_433_1469.n230 a_433_1469.n28 0.257202
R2660 a_433_1469.n236 a_433_1469.n25 0.257202
R2661 a_433_1469.n281 a_433_1469.n4 0.257202
R2662 a_433_1469.n288 a_433_1469.n287 0.257202
R2663 a_433_1469.n296 a_433_1469.n295 0.257202
R2664 a_433_1469.n207 a_433_1469.n206 0.25305
R2665 a_433_1469.n304 a_433_1469.n303 0.25305
R2666 a_433_1469.n199 a_433_1469.n198 0.24999
R2667 a_433_1469.n149 a_433_1469.n146 0.24999
R2668 a_433_1469.n165 a_433_1469.n40 0.228625
R2669 a_433_1469.n164 a_433_1469.n162 0.213993
R2670 a_433_1469.n165 a_433_1469.n164 0.211872
R2671 a_433_1469.n146 a_433_1469.n106 0.192808
R2672 a_433_1469.n91 a_433_1469.n90 0.192808
R2673 a_433_1469.n265 a_433_1469.n264 0.190404
R2674 a_433_1469.n243 a_433_1469.n242 0.190404
R2675 a_433_1469.n287 a_433_1469.n286 0.188
R2676 a_433_1469.n282 a_433_1469.n281 0.188
R2677 a_433_1469.n281 a_433_1469.n280 0.188
R2678 a_433_1469.n276 a_433_1469.n275 0.188
R2679 a_433_1469.n275 a_433_1469.n274 0.188
R2680 a_433_1469.n254 a_433_1469.n253 0.188
R2681 a_433_1469.n253 a_433_1469.n252 0.188
R2682 a_433_1469.n237 a_433_1469.n236 0.188
R2683 a_433_1469.n236 a_433_1469.n235 0.188
R2684 a_433_1469.n231 a_433_1469.n230 0.188
R2685 a_433_1469.n230 a_433_1469.n229 0.188
R2686 a_433_1469.n129 a_433_1469.n128 0.188
R2687 a_433_1469.n130 a_433_1469.n129 0.188
R2688 a_433_1469.n140 a_433_1469.n139 0.188
R2689 a_433_1469.n141 a_433_1469.n140 0.188
R2690 a_433_1469.n102 a_433_1469.n101 0.188
R2691 a_433_1469.n101 a_433_1469.n100 0.188
R2692 a_433_1469.n264 a_433_1469.n263 0.185596
R2693 a_433_1469.n242 a_433_1469.n241 0.185596
R2694 a_433_1469.n146 a_433_1469.n145 0.183192
R2695 a_433_1469.n90 a_433_1469.n89 0.183192
R2696 a_433_1469.n286 a_433_1469.n2 0.173577
R2697 a_433_1469.n282 a_433_1469.n2 0.173577
R2698 a_433_1469.n280 a_433_1469.n5 0.173577
R2699 a_433_1469.n276 a_433_1469.n5 0.173577
R2700 a_433_1469.n274 a_433_1469.n8 0.173577
R2701 a_433_1469.n270 a_433_1469.n8 0.173577
R2702 a_433_1469.n269 a_433_1469.n10 0.173577
R2703 a_433_1469.n265 a_433_1469.n10 0.173577
R2704 a_433_1469.n263 a_433_1469.n13 0.173577
R2705 a_433_1469.n259 a_433_1469.n13 0.173577
R2706 a_433_1469.n258 a_433_1469.n15 0.173577
R2707 a_433_1469.n254 a_433_1469.n15 0.173577
R2708 a_433_1469.n252 a_433_1469.n18 0.173577
R2709 a_433_1469.n248 a_433_1469.n18 0.173577
R2710 a_433_1469.n247 a_433_1469.n20 0.173577
R2711 a_433_1469.n243 a_433_1469.n20 0.173577
R2712 a_433_1469.n241 a_433_1469.n23 0.173577
R2713 a_433_1469.n237 a_433_1469.n23 0.173577
R2714 a_433_1469.n235 a_433_1469.n26 0.173577
R2715 a_433_1469.n231 a_433_1469.n26 0.173577
R2716 a_433_1469.n229 a_433_1469.n29 0.173577
R2717 a_433_1469.n225 a_433_1469.n29 0.173577
R2718 a_433_1469.n119 a_433_1469.n117 0.173577
R2719 a_433_1469.n123 a_433_1469.n117 0.173577
R2720 a_433_1469.n124 a_433_1469.n115 0.173577
R2721 a_433_1469.n128 a_433_1469.n115 0.173577
R2722 a_433_1469.n130 a_433_1469.n112 0.173577
R2723 a_433_1469.n134 a_433_1469.n112 0.173577
R2724 a_433_1469.n135 a_433_1469.n110 0.173577
R2725 a_433_1469.n139 a_433_1469.n110 0.173577
R2726 a_433_1469.n141 a_433_1469.n107 0.173577
R2727 a_433_1469.n145 a_433_1469.n107 0.173577
R2728 a_433_1469.n106 a_433_1469.n68 0.173577
R2729 a_433_1469.n102 a_433_1469.n68 0.173577
R2730 a_433_1469.n100 a_433_1469.n71 0.173577
R2731 a_433_1469.n96 a_433_1469.n71 0.173577
R2732 a_433_1469.n95 a_433_1469.n73 0.173577
R2733 a_433_1469.n91 a_433_1469.n73 0.173577
R2734 a_433_1469.n89 a_433_1469.n76 0.173577
R2735 a_433_1469.n85 a_433_1469.n76 0.173577
R2736 a_433_1469.n84 a_433_1469.n78 0.173577
R2737 a_433_1469.n80 a_433_1469.n78 0.173577
R2738 a_433_1469.n293 a_433_1469.n1 0.121712
R2739 a_433_1469.n301 a_433_1469.n294 0.121712
R2740 a_433_1469.n309 a_433_1469.n302 0.121712
R2741 a_433_1469.n221 a_433_1469.n32 0.121712
R2742 a_433_1469.n222 a_433_1469.n31 0.121712
R2743 a_433_1469.n195 a_433_1469.n194 0.121712
R2744 a_433_1469.n196 a_433_1469.n191 0.121712
R2745 a_433_1469.n204 a_433_1469.n197 0.121712
R2746 a_433_1469.n212 a_433_1469.n205 0.121712
R2747 a_433_1469.n203 a_433_1469.n202 0.121712
R2748 a_433_1469.n182 a_433_1469.n181 0.121712
R2749 a_433_1469.n183 a_433_1469.n178 0.121712
R2750 a_433_1469.n54 a_433_1469.n53 0.121712
R2751 a_433_1469.n55 a_433_1469.n50 0.121712
R2752 a_433_1469.n292 a_433_1469.n291 0.121712
R2753 a_433_1469.n300 a_433_1469.n299 0.121712
R2754 a_433_1469.n211 a_433_1469.n210 0.117924
R2755 a_433_1469.n308 a_433_1469.n307 0.117924
R2756 a_433_1469.n150 a_433_1469.n67 0.06917
R2757 a_433_1469.n150 a_433_1469.n149 0.0676037
R2758 a_433_1469.n211 a_433_1469.n207 0.0194394
R2759 a_433_1469.n308 a_433_1469.n304 0.0194394
R2760 a_433_1469.n224 a_433_1469.n31 0.00807576
R2761 a_433_1469.n195 a_433_1469.n28 0.00807576
R2762 a_433_1469.n203 a_433_1469.n199 0.00807576
R2763 a_433_1469.n182 a_433_1469.n25 0.00807576
R2764 a_433_1469.n54 a_433_1469.n4 0.00807576
R2765 a_433_1469.n292 a_433_1469.n288 0.00807576
R2766 a_433_1469.n300 a_433_1469.n296 0.00807576
C10 VBIAS VGND 7.41213f
C11 D2 VGND 5.49798f
C12 VINM VGND 1.80918f
C13 D1 VGND 1.87622f
C14 VINP VGND 2.18277f
C15 a_433_1469.n0 VGND 0.06181f
C16 a_433_1469.n1 VGND 0.07708f
C17 a_433_1469.n2 VGND 0.01091f
C18 a_433_1469.n3 VGND 0.00713f
C19 a_433_1469.t87 VGND 0.11073f
C20 a_433_1469.n4 VGND 0.01458f
C21 a_433_1469.n5 VGND 0.01091f
C22 a_433_1469.n6 VGND 0.00713f
C23 a_433_1469.t90 VGND 0.11073f
C24 a_433_1469.t94 VGND 0.01457f
C25 a_433_1469.t91 VGND 0.01457f
C26 a_433_1469.n7 VGND 0.02992f
C27 a_433_1469.n8 VGND 0.01091f
C28 a_433_1469.n9 VGND 0.00713f
C29 a_433_1469.t93 VGND 0.11073f
C30 a_433_1469.n10 VGND 0.01091f
C31 a_433_1469.n11 VGND 0.00713f
C32 a_433_1469.t96 VGND 0.11073f
C33 a_433_1469.t100 VGND 0.01457f
C34 a_433_1469.t97 VGND 0.01457f
C35 a_433_1469.n12 VGND 0.02992f
C36 a_433_1469.n13 VGND 0.01091f
C37 a_433_1469.n14 VGND 0.00713f
C38 a_433_1469.t99 VGND 0.11073f
C39 a_433_1469.n15 VGND 0.01091f
C40 a_433_1469.n16 VGND 0.00713f
C41 a_433_1469.t102 VGND 0.11073f
C42 a_433_1469.t106 VGND 0.01457f
C43 a_433_1469.t103 VGND 0.01457f
C44 a_433_1469.n17 VGND 0.02992f
C45 a_433_1469.n18 VGND 0.01091f
C46 a_433_1469.n19 VGND 0.00713f
C47 a_433_1469.t105 VGND 0.11073f
C48 a_433_1469.n20 VGND 0.01091f
C49 a_433_1469.n21 VGND 0.00713f
C50 a_433_1469.t108 VGND 0.11073f
C51 a_433_1469.t113 VGND 0.01457f
C52 a_433_1469.t109 VGND 0.01457f
C53 a_433_1469.n22 VGND 0.02992f
C54 a_433_1469.n23 VGND 0.01091f
C55 a_433_1469.n24 VGND 0.00713f
C56 a_433_1469.t111 VGND 0.11073f
C57 a_433_1469.n25 VGND 0.01458f
C58 a_433_1469.n26 VGND 0.01091f
C59 a_433_1469.n27 VGND 0.00713f
C60 a_433_1469.t114 VGND 0.11073f
C61 a_433_1469.n28 VGND 0.01458f
C62 a_433_1469.n29 VGND 0.01091f
C63 a_433_1469.n30 VGND 0.00713f
C64 a_433_1469.t117 VGND 0.11073f
C65 a_433_1469.n31 VGND 0.00654f
C66 a_433_1469.n32 VGND 0.04067f
C67 a_433_1469.n33 VGND 0.05655f
C68 a_433_1469.n34 VGND 0.10711f
C69 a_433_1469.n35 VGND 0.09175f
C70 a_433_1469.t104 VGND 0.01457f
C71 a_433_1469.t101 VGND 0.01457f
C72 a_433_1469.n36 VGND 0.03069f
C73 a_433_1469.n37 VGND 0.15141f
C74 a_433_1469.t7 VGND 0.01457f
C75 a_433_1469.t6 VGND 0.01457f
C76 a_433_1469.n38 VGND 0.03656f
C77 a_433_1469.t5 VGND 0.01457f
C78 a_433_1469.t4 VGND 0.01457f
C79 a_433_1469.n39 VGND 0.03554f
C80 a_433_1469.n40 VGND 0.55302f
C81 a_433_1469.t1 VGND 0.01457f
C82 a_433_1469.t0 VGND 0.01457f
C83 a_433_1469.n41 VGND 0.03599f
C84 a_433_1469.n42 VGND 0.29395f
C85 a_433_1469.t26 VGND 0.04933f
C86 a_433_1469.n43 VGND 0.17256f
C87 a_433_1469.t61 VGND 0.04933f
C88 a_433_1469.n44 VGND 0.12474f
C89 a_433_1469.t73 VGND 0.04933f
C90 a_433_1469.n45 VGND 0.12417f
C91 a_433_1469.t86 VGND 0.04933f
C92 a_433_1469.n46 VGND 0.16235f
C93 a_433_1469.n47 VGND 0.2905f
C94 a_433_1469.n48 VGND 0.05655f
C95 a_433_1469.n49 VGND 0.07981f
C96 a_433_1469.n50 VGND 0.07708f
C97 a_433_1469.t92 VGND 0.01457f
C98 a_433_1469.t88 VGND 0.01457f
C99 a_433_1469.n51 VGND 0.02914f
C100 a_433_1469.n52 VGND 0.0058f
C101 a_433_1469.n53 VGND 0.0174f
C102 a_433_1469.n54 VGND 0.00654f
C103 a_433_1469.n55 VGND 0.04067f
C104 a_433_1469.t8 VGND 0.01457f
C105 a_433_1469.t76 VGND 0.01457f
C106 a_433_1469.n56 VGND 0.03069f
C107 a_433_1469.n57 VGND 0.11022f
C108 a_433_1469.t16 VGND 0.01457f
C109 a_433_1469.t64 VGND 0.01457f
C110 a_433_1469.n58 VGND 0.03069f
C111 a_433_1469.n59 VGND 0.11438f
C112 a_433_1469.t31 VGND 0.01457f
C113 a_433_1469.t29 VGND 0.01457f
C114 a_433_1469.n60 VGND 0.03069f
C115 a_433_1469.n61 VGND 0.16216f
C116 a_433_1469.n62 VGND 0.08438f
C117 a_433_1469.t12 VGND 0.01457f
C118 a_433_1469.t11 VGND 0.01457f
C119 a_433_1469.n63 VGND 0.0298f
C120 a_433_1469.n64 VGND 0.06985f
C121 a_433_1469.t20 VGND 0.01457f
C122 a_433_1469.t19 VGND 0.01457f
C123 a_433_1469.n65 VGND 0.02979f
C124 a_433_1469.n66 VGND 0.0571f
C125 a_433_1469.n67 VGND 0.03547f
C126 a_433_1469.n68 VGND 0.01091f
C127 a_433_1469.n69 VGND 0.00713f
C128 a_433_1469.t42 VGND 0.11073f
C129 a_433_1469.t47 VGND 0.01457f
C130 a_433_1469.t43 VGND 0.01457f
C131 a_433_1469.n70 VGND 0.02991f
C132 a_433_1469.n71 VGND 0.01091f
C133 a_433_1469.n72 VGND 0.00713f
C134 a_433_1469.t45 VGND 0.11073f
C135 a_433_1469.n73 VGND 0.01091f
C136 a_433_1469.n74 VGND 0.00713f
C137 a_433_1469.t48 VGND 0.11073f
C138 a_433_1469.t53 VGND 0.01457f
C139 a_433_1469.t50 VGND 0.01457f
C140 a_433_1469.n75 VGND 0.02991f
C141 a_433_1469.n76 VGND 0.01091f
C142 a_433_1469.n77 VGND 0.00713f
C143 a_433_1469.t51 VGND 0.11073f
C144 a_433_1469.n78 VGND 0.01091f
C145 a_433_1469.n79 VGND 0.00713f
C146 a_433_1469.t54 VGND 0.11073f
C147 a_433_1469.t57 VGND 0.17225f
C148 a_433_1469.n80 VGND 0.10551f
C149 a_433_1469.n81 VGND 0.01034f
C150 a_433_1469.n82 VGND 0.08391f
C151 a_433_1469.n83 VGND 0.00417f
C152 a_433_1469.n84 VGND 0.02344f
C153 a_433_1469.n85 VGND 0.01727f
C154 a_433_1469.n86 VGND 0.01034f
C155 a_433_1469.n87 VGND 0.08391f
C156 a_433_1469.n88 VGND 0.00417f
C157 a_433_1469.n89 VGND 0.01738f
C158 a_433_1469.n90 VGND 0.05745f
C159 a_433_1469.n91 VGND 0.01152f
C160 a_433_1469.n92 VGND 0.01034f
C161 a_433_1469.n93 VGND 0.08391f
C162 a_433_1469.n94 VGND 0.00417f
C163 a_433_1469.n95 VGND 0.02344f
C164 a_433_1469.n96 VGND 0.01727f
C165 a_433_1469.n97 VGND 0.01034f
C166 a_433_1469.n98 VGND 0.08391f
C167 a_433_1469.n99 VGND 0.00417f
C168 a_433_1469.n100 VGND 0.01753f
C169 a_433_1469.n101 VGND 0.05745f
C170 a_433_1469.n102 VGND 0.01136f
C171 a_433_1469.n103 VGND 0.01034f
C172 a_433_1469.n104 VGND 0.08391f
C173 a_433_1469.n105 VGND 0.00417f
C174 a_433_1469.n106 VGND 0.01769f
C175 a_433_1469.n107 VGND 0.01091f
C176 a_433_1469.t39 VGND 0.11073f
C177 a_433_1469.n108 VGND 0.08391f
C178 a_433_1469.t40 VGND 0.01457f
C179 a_433_1469.t38 VGND 0.01457f
C180 a_433_1469.n109 VGND 0.02991f
C181 a_433_1469.n110 VGND 0.01091f
C182 a_433_1469.t36 VGND 0.11073f
C183 a_433_1469.n111 VGND 0.08391f
C184 a_433_1469.n112 VGND 0.01091f
C185 a_433_1469.t33 VGND 0.11073f
C186 a_433_1469.n113 VGND 0.08391f
C187 a_433_1469.t35 VGND 0.01457f
C188 a_433_1469.t32 VGND 0.01457f
C189 a_433_1469.n114 VGND 0.02991f
C190 a_433_1469.n115 VGND 0.01091f
C191 a_433_1469.t30 VGND 0.11073f
C192 a_433_1469.n116 VGND 0.08391f
C193 a_433_1469.n117 VGND 0.01091f
C194 a_433_1469.t27 VGND 0.11073f
C195 a_433_1469.n118 VGND 0.08391f
C196 a_433_1469.t24 VGND 0.17225f
C197 a_433_1469.n119 VGND 0.11168f
C198 a_433_1469.n120 VGND 0.00417f
C199 a_433_1469.n121 VGND 0.00713f
C200 a_433_1469.n122 VGND 0.01034f
C201 a_433_1469.n123 VGND 0.01727f
C202 a_433_1469.n124 VGND 0.02344f
C203 a_433_1469.n125 VGND 0.00417f
C204 a_433_1469.n126 VGND 0.00713f
C205 a_433_1469.n127 VGND 0.01034f
C206 a_433_1469.n128 VGND 0.01136f
C207 a_433_1469.n129 VGND 0.05745f
C208 a_433_1469.n130 VGND 0.01753f
C209 a_433_1469.n131 VGND 0.00417f
C210 a_433_1469.n132 VGND 0.00713f
C211 a_433_1469.n133 VGND 0.01034f
C212 a_433_1469.n134 VGND 0.01727f
C213 a_433_1469.n135 VGND 0.02344f
C214 a_433_1469.n136 VGND 0.00417f
C215 a_433_1469.n137 VGND 0.00713f
C216 a_433_1469.n138 VGND 0.01034f
C217 a_433_1469.n139 VGND 0.01136f
C218 a_433_1469.n140 VGND 0.05745f
C219 a_433_1469.n141 VGND 0.01753f
C220 a_433_1469.n142 VGND 0.00417f
C221 a_433_1469.n143 VGND 0.00713f
C222 a_433_1469.n144 VGND 0.01034f
C223 a_433_1469.n145 VGND 0.01121f
C224 a_433_1469.n146 VGND 0.02f
C225 a_433_1469.t44 VGND 0.01457f
C226 a_433_1469.t41 VGND 0.01457f
C227 a_433_1469.n147 VGND 0.02914f
C228 a_433_1469.n148 VGND 0.0058f
C229 a_433_1469.n149 VGND 0.02015f
C230 a_433_1469.n150 VGND 0.05892f
C231 a_433_1469.n151 VGND 0.14842f
C232 a_433_1469.n152 VGND 0.10689f
C233 a_433_1469.t37 VGND 0.01457f
C234 a_433_1469.t34 VGND 0.01457f
C235 a_433_1469.n153 VGND 0.03069f
C236 a_433_1469.n154 VGND 0.16216f
C237 a_433_1469.t18 VGND 0.01457f
C238 a_433_1469.t17 VGND 0.01457f
C239 a_433_1469.n155 VGND 0.03069f
C240 a_433_1469.n156 VGND 0.11438f
C241 a_433_1469.t10 VGND 0.01457f
C242 a_433_1469.t9 VGND 0.01457f
C243 a_433_1469.n157 VGND 0.03069f
C244 a_433_1469.n158 VGND 0.11358f
C245 a_433_1469.t98 VGND 0.01457f
C246 a_433_1469.t95 VGND 0.01457f
C247 a_433_1469.n159 VGND 0.03069f
C248 a_433_1469.n160 VGND 0.11303f
C249 a_433_1469.n161 VGND 0.09767f
C250 a_433_1469.n162 VGND 0.30123f
C251 a_433_1469.t3 VGND 0.01457f
C252 a_433_1469.t2 VGND 0.01457f
C253 a_433_1469.n163 VGND 0.03554f
C254 a_433_1469.n164 VGND 0.25952f
C255 a_433_1469.n165 VGND 0.06541f
C256 a_433_1469.n166 VGND 0.09766f
C257 a_433_1469.n167 VGND 0.09101f
C258 a_433_1469.t49 VGND 0.01457f
C259 a_433_1469.t46 VGND 0.01457f
C260 a_433_1469.n168 VGND 0.03069f
C261 a_433_1469.n169 VGND 0.16216f
C262 a_433_1469.t22 VGND 0.01457f
C263 a_433_1469.t21 VGND 0.01457f
C264 a_433_1469.n170 VGND 0.03069f
C265 a_433_1469.n171 VGND 0.11431f
C266 a_433_1469.t14 VGND 0.01457f
C267 a_433_1469.t13 VGND 0.01457f
C268 a_433_1469.n172 VGND 0.03069f
C269 a_433_1469.n173 VGND 0.11411f
C270 a_433_1469.t110 VGND 0.01457f
C271 a_433_1469.t107 VGND 0.01457f
C272 a_433_1469.n174 VGND 0.03069f
C273 a_433_1469.n175 VGND 0.15179f
C274 a_433_1469.n176 VGND 0.10307f
C275 a_433_1469.n177 VGND 0.07898f
C276 a_433_1469.n178 VGND 0.07708f
C277 a_433_1469.t116 VGND 0.01457f
C278 a_433_1469.t112 VGND 0.01457f
C279 a_433_1469.n179 VGND 0.02914f
C280 a_433_1469.n180 VGND 0.0058f
C281 a_433_1469.n181 VGND 0.0174f
C282 a_433_1469.n182 VGND 0.00654f
C283 a_433_1469.n183 VGND 0.04067f
C284 a_433_1469.t80 VGND 0.01457f
C285 a_433_1469.t15 VGND 0.01457f
C286 a_433_1469.n184 VGND 0.03069f
C287 a_433_1469.n185 VGND 0.11022f
C288 a_433_1469.t68 VGND 0.01457f
C289 a_433_1469.t23 VGND 0.01457f
C290 a_433_1469.n186 VGND 0.03069f
C291 a_433_1469.n187 VGND 0.11438f
C292 a_433_1469.t56 VGND 0.01457f
C293 a_433_1469.t52 VGND 0.01457f
C294 a_433_1469.n188 VGND 0.03069f
C295 a_433_1469.n189 VGND 0.16216f
C296 a_433_1469.n190 VGND 0.08423f
C297 a_433_1469.n191 VGND 0.07708f
C298 a_433_1469.t118 VGND 0.01457f
C299 a_433_1469.t115 VGND 0.01457f
C300 a_433_1469.n192 VGND 0.02914f
C301 a_433_1469.n193 VGND 0.0058f
C302 a_433_1469.n194 VGND 0.0174f
C303 a_433_1469.n195 VGND 0.00654f
C304 a_433_1469.n196 VGND 0.03731f
C305 a_433_1469.n197 VGND 0.03731f
C306 a_433_1469.t81 VGND 0.17204f
C307 a_433_1469.t78 VGND 0.17204f
C308 a_433_1469.n198 VGND 0.18507f
C309 a_433_1469.n199 VGND 0.01434f
C310 a_433_1469.t82 VGND 0.01457f
C311 a_433_1469.t79 VGND 0.01457f
C312 a_433_1469.n200 VGND 0.02914f
C313 a_433_1469.n201 VGND 0.0058f
C314 a_433_1469.n202 VGND 0.0174f
C315 a_433_1469.n203 VGND 0.00654f
C316 a_433_1469.n204 VGND 0.03721f
C317 a_433_1469.n205 VGND 0.03722f
C318 a_433_1469.t69 VGND 0.17204f
C319 a_433_1469.t66 VGND 0.17204f
C320 a_433_1469.n206 VGND 0.18502f
C321 a_433_1469.n207 VGND 0.01469f
C322 a_433_1469.t70 VGND 0.01457f
C323 a_433_1469.t67 VGND 0.01457f
C324 a_433_1469.n208 VGND 0.02914f
C325 a_433_1469.n209 VGND 0.0058f
C326 a_433_1469.n210 VGND 0.01759f
C327 a_433_1469.n211 VGND 0.00692f
C328 a_433_1469.n212 VGND 0.04134f
C329 a_433_1469.t58 VGND 0.01457f
C330 a_433_1469.t55 VGND 0.01457f
C331 a_433_1469.n213 VGND 0.03069f
C332 a_433_1469.n214 VGND 0.15881f
C333 a_433_1469.n215 VGND 0.06158f
C334 a_433_1469.t83 VGND 0.04933f
C335 a_433_1469.n216 VGND 0.12071f
C336 a_433_1469.t71 VGND 0.04934f
C337 a_433_1469.n217 VGND 0.12487f
C338 a_433_1469.t59 VGND 0.04933f
C339 a_433_1469.n218 VGND 0.17265f
C340 a_433_1469.n219 VGND 0.29091f
C341 a_433_1469.n220 VGND 0.28589f
C342 a_433_1469.n221 VGND 0.07708f
C343 a_433_1469.n222 VGND 0.0174f
C344 a_433_1469.t119 VGND 0.04699f
C345 a_433_1469.n223 VGND 0.01709f
C346 a_433_1469.n224 VGND 0.02237f
C347 a_433_1469.n225 VGND 0.02197f
C348 a_433_1469.n226 VGND 0.01034f
C349 a_433_1469.n227 VGND 0.08391f
C350 a_433_1469.n228 VGND 0.00417f
C351 a_433_1469.n229 VGND 0.01753f
C352 a_433_1469.n230 VGND 0.02022f
C353 a_433_1469.n231 VGND 0.01136f
C354 a_433_1469.n232 VGND 0.01034f
C355 a_433_1469.n233 VGND 0.08391f
C356 a_433_1469.n234 VGND 0.00417f
C357 a_433_1469.n235 VGND 0.01753f
C358 a_433_1469.n236 VGND 0.02022f
C359 a_433_1469.n237 VGND 0.01136f
C360 a_433_1469.n238 VGND 0.01034f
C361 a_433_1469.n239 VGND 0.08391f
C362 a_433_1469.n240 VGND 0.00417f
C363 a_433_1469.n241 VGND 0.01746f
C364 a_433_1469.n242 VGND 0.05805f
C365 a_433_1469.n243 VGND 0.01144f
C366 a_433_1469.n244 VGND 0.01034f
C367 a_433_1469.n245 VGND 0.08391f
C368 a_433_1469.n246 VGND 0.00417f
C369 a_433_1469.n247 VGND 0.02344f
C370 a_433_1469.n248 VGND 0.01727f
C371 a_433_1469.n249 VGND 0.01034f
C372 a_433_1469.n250 VGND 0.08391f
C373 a_433_1469.n251 VGND 0.00417f
C374 a_433_1469.n252 VGND 0.01753f
C375 a_433_1469.n253 VGND 0.05805f
C376 a_433_1469.n254 VGND 0.01136f
C377 a_433_1469.n255 VGND 0.01034f
C378 a_433_1469.n256 VGND 0.08391f
C379 a_433_1469.n257 VGND 0.00417f
C380 a_433_1469.n258 VGND 0.02344f
C381 a_433_1469.n259 VGND 0.01727f
C382 a_433_1469.n260 VGND 0.01034f
C383 a_433_1469.n261 VGND 0.08391f
C384 a_433_1469.n262 VGND 0.00417f
C385 a_433_1469.n263 VGND 0.01746f
C386 a_433_1469.n264 VGND 0.05805f
C387 a_433_1469.n265 VGND 0.01144f
C388 a_433_1469.n266 VGND 0.01034f
C389 a_433_1469.n267 VGND 0.08391f
C390 a_433_1469.n268 VGND 0.00417f
C391 a_433_1469.n269 VGND 0.02344f
C392 a_433_1469.n270 VGND 0.01727f
C393 a_433_1469.n271 VGND 0.01034f
C394 a_433_1469.n272 VGND 0.08391f
C395 a_433_1469.n273 VGND 0.00417f
C396 a_433_1469.n274 VGND 0.01753f
C397 a_433_1469.n275 VGND 0.05805f
C398 a_433_1469.n276 VGND 0.01136f
C399 a_433_1469.n277 VGND 0.01034f
C400 a_433_1469.n278 VGND 0.08391f
C401 a_433_1469.n279 VGND 0.00417f
C402 a_433_1469.n280 VGND 0.01753f
C403 a_433_1469.n281 VGND 0.02022f
C404 a_433_1469.n282 VGND 0.01136f
C405 a_433_1469.n283 VGND 0.01034f
C406 a_433_1469.n284 VGND 0.08391f
C407 a_433_1469.n285 VGND 0.00417f
C408 a_433_1469.n286 VGND 0.01753f
C409 a_433_1469.t84 VGND 0.17204f
C410 a_433_1469.n287 VGND 0.10275f
C411 a_433_1469.n288 VGND 0.01458f
C412 a_433_1469.t89 VGND 0.01457f
C413 a_433_1469.t85 VGND 0.01457f
C414 a_433_1469.n289 VGND 0.02914f
C415 a_433_1469.n290 VGND 0.0058f
C416 a_433_1469.n291 VGND 0.0174f
C417 a_433_1469.n292 VGND 0.00654f
C418 a_433_1469.n293 VGND 0.03731f
C419 a_433_1469.n294 VGND 0.03731f
C420 a_433_1469.t75 VGND 0.17204f
C421 a_433_1469.t72 VGND 0.17204f
C422 a_433_1469.n295 VGND 0.18529f
C423 a_433_1469.n296 VGND 0.01458f
C424 a_433_1469.t77 VGND 0.01457f
C425 a_433_1469.t74 VGND 0.01457f
C426 a_433_1469.n297 VGND 0.02914f
C427 a_433_1469.n298 VGND 0.0058f
C428 a_433_1469.n299 VGND 0.0174f
C429 a_433_1469.n300 VGND 0.00654f
C430 a_433_1469.n301 VGND 0.03721f
C431 a_433_1469.n302 VGND 0.03722f
C432 a_433_1469.t63 VGND 0.17204f
C433 a_433_1469.t60 VGND 0.17205f
C434 a_433_1469.n303 VGND 0.18506f
C435 a_433_1469.n304 VGND 0.01469f
C436 a_433_1469.t65 VGND 0.01457f
C437 a_433_1469.t62 VGND 0.01457f
C438 a_433_1469.n305 VGND 0.02914f
C439 a_433_1469.n306 VGND 0.0058f
C440 a_433_1469.n307 VGND 0.01759f
C441 a_433_1469.n308 VGND 0.00692f
C442 a_433_1469.n309 VGND 0.04134f
C443 a_433_1469.n310 VGND 0.15881f
C444 a_433_1469.t25 VGND 0.01457f
C445 a_433_1469.n311 VGND 0.03069f
C446 a_433_1469.t28 VGND 0.01457f
C447 VINP.n0 VGND 0.04857f
C448 VINP.n1 VGND 0.0253f
C449 VINP.n2 VGND 0.01015f
C450 VINP.n3 VGND 0.01176f
C451 VINP.t7 VGND 0.18255f
C452 VINP.n4 VGND 0.01141f
C453 VINP.n5 VGND 0.01176f
C454 VINP.t6 VGND 0.18255f
C455 VINP.n6 VGND 0.0414f
C456 VINP.n7 VGND 0.01015f
C457 VINP.n8 VGND 0.04699f
C458 VINP.n9 VGND 0.0253f
C459 VINP.n10 VGND 0.01141f
C460 VINP.n11 VGND 0.01141f
C461 VINP.n12 VGND 0.01176f
C462 VINP.t4 VGND 0.18255f
C463 VINP.n13 VGND 0.01015f
C464 VINP.n14 VGND 0.02517f
C465 VINP.n15 VGND 0.01015f
C466 VINP.n16 VGND 0.01176f
C467 VINP.t0 VGND 0.18255f
C468 VINP.n17 VGND 0.01716f
C469 VINP.n18 VGND 0.13834f
C470 VINP.n19 VGND 0.00695f
C471 VINP.n20 VGND 0.03536f
C472 VINP.n21 VGND 0.05649f
C473 VINP.n22 VGND 0.11412f
C474 VINP.n23 VGND 0.0253f
C475 VINP.n24 VGND 0.01015f
C476 VINP.n25 VGND 0.01176f
C477 VINP.t1 VGND 0.18255f
C478 VINP.n26 VGND 0.02482f
C479 VINP.n27 VGND 0.01716f
C480 VINP.n28 VGND 0.13834f
C481 VINP.n29 VGND 0.00695f
C482 VINP.n30 VGND 0.03503f
C483 VINP.n31 VGND 0.0253f
C484 VINP.n32 VGND 0.0481f
C485 VINP.n33 VGND 0.0481f
C486 VINP.n34 VGND 0.0253f
C487 VINP.n35 VGND 0.01015f
C488 VINP.n36 VGND 0.01176f
C489 VINP.t2 VGND 0.18255f
C490 VINP.n37 VGND 0.025f
C491 VINP.n38 VGND 0.01717f
C492 VINP.n39 VGND 0.13834f
C493 VINP.n40 VGND 0.00694f
C494 VINP.n41 VGND 0.03485f
C495 VINP.n42 VGND 0.0253f
C496 VINP.n43 VGND 0.04667f
C497 VINP.n44 VGND 0.04667f
C498 VINP.n45 VGND 0.0253f
C499 VINP.n46 VGND 0.01015f
C500 VINP.n47 VGND 0.01176f
C501 VINP.t3 VGND 0.18255f
C502 VINP.n48 VGND 0.02465f
C503 VINP.n49 VGND 0.01715f
C504 VINP.n50 VGND 0.13834f
C505 VINP.n51 VGND 0.00696f
C506 VINP.n52 VGND 0.03521f
C507 VINP.n53 VGND 0.0253f
C508 VINP.n54 VGND 0.04857f
C509 VINP.n55 VGND 0.04857f
C510 VINP.n56 VGND 0.04699f
C511 VINP.n57 VGND 0.0253f
C512 VINP.n58 VGND 0.0253f
C513 VINP.n59 VGND 0.02729f
C514 VINP.n60 VGND 0.01719f
C515 VINP.n61 VGND 0.13834f
C516 VINP.n62 VGND 0.00687f
C517 VINP.n63 VGND 0.04077f
C518 VINP.n64 VGND 0.03091f
C519 VINP.n65 VGND 0.01705f
C520 VINP.t5 VGND 0.18255f
C521 VINP.n66 VGND 0.13834f
C522 VINP.n67 VGND 0.00687f
C523 VINP.n68 VGND 0.01176f
C524 VINP.n69 VGND 0.01015f
C525 VINP.n70 VGND 0.01141f
C526 VINP.n71 VGND 0.0253f
C527 VINP.n72 VGND 0.04778f
C528 VINP.n73 VGND 0.04778f
C529 VINP.n74 VGND 0.04857f
C530 VINP.n75 VGND 0.0253f
C531 VINP.n76 VGND 0.0253f
C532 VINP.n77 VGND 0.01141f
C533 VINP.n78 VGND 0.03107f
C534 VINP.n79 VGND 0.01705f
C535 VINP.n80 VGND 0.13834f
C536 VINP.n81 VGND 0.00687f
C537 VINP.n82 VGND 0.04125f
C538 VINP.n83 VGND 0.01141f
C539 VINP.n84 VGND 0.0422f
C540 VINP.n85 VGND 0.00687f
C541 VINP.n86 VGND 0.13834f
C542 VINP.n87 VGND 0.01715f
C543 VINP.n88 VGND 0.0258f
C544 VINP.n89 VGND 0.0253f
C545 VINP.n90 VGND 0.20092f
C546 D1.t4 VGND 0.04267f
C547 D1.t1 VGND 0.04267f
C548 D1.n0 VGND 0.1085f
C549 D1.n1 VGND 1.19924f
C550 D1.t2 VGND 0.04267f
C551 D1.t0 VGND 0.04267f
C552 D1.n2 VGND 0.10849f
C553 D1.n3 VGND 0.87303f
C554 D1.t7 VGND 0.04267f
C555 D1.t3 VGND 0.04267f
C556 D1.n4 VGND 0.10849f
C557 D1.n5 VGND 0.87391f
C558 D1.t6 VGND 0.04267f
C559 D1.t5 VGND 0.04267f
C560 D1.n6 VGND 0.10849f
C561 D1.n7 VGND 2.71881f
C562 D1.n8 VGND 2.59296f
C563 VINM.n0 VGND 0.04524f
C564 VINM.n1 VGND 0.0238f
C565 VINM.n2 VGND 0.00954f
C566 VINM.t3 VGND 0.26724f
C567 VINM.n3 VGND 0.01106f
C568 VINM.t2 VGND 0.17172f
C569 VINM.n4 VGND 0.01074f
C570 VINM.n5 VGND 0.01106f
C571 VINM.t1 VGND 0.17172f
C572 VINM.n6 VGND 0.0388f
C573 VINM.n7 VGND 0.00954f
C574 VINM.n8 VGND 0.02585f
C575 VINM.n9 VGND 0.01616f
C576 VINM.t0 VGND 0.17172f
C577 VINM.n10 VGND 0.13013f
C578 VINM.n11 VGND 0.00647f
C579 VINM.n12 VGND 0.01106f
C580 VINM.n13 VGND 0.00954f
C581 VINM.n14 VGND 0.01105f
C582 VINM.n15 VGND 0.05388f
C583 VINM.n16 VGND 0.11406f
C584 VINM.n17 VGND 0.04524f
C585 VINM.n18 VGND 0.0238f
C586 VINM.n19 VGND 0.0238f
C587 VINM.n20 VGND 0.01074f
C588 VINM.n21 VGND 0.02923f
C589 VINM.n22 VGND 0.01603f
C590 VINM.n23 VGND 0.13013f
C591 VINM.n24 VGND 0.00647f
C592 VINM.n25 VGND 0.0388f
C593 VINM.n26 VGND 0.01074f
C594 VINM.n27 VGND 0.02968f
C595 VINM.n28 VGND 0.01603f
C596 VINM.n29 VGND 0.13013f
C597 VINM.n30 VGND 0.00647f
C598 VINM.n31 VGND 0.23616f
C599 VINM.n32 VGND 0.01074f
C600 VINM.n33 VGND 0.0238f
C601 VINM.n34 VGND 0.08924f
C602 VINM.n35 VGND 0.08924f
C603 VINM.n36 VGND 0.0238f
C604 VINM.n37 VGND 0.00954f
C605 VINM.n38 VGND 0.01106f
C606 VINM.t4 VGND 0.17172f
C607 VINM.n39 VGND 0.02341f
C608 VINM.n40 VGND 0.01614f
C609 VINM.n41 VGND 0.13013f
C610 VINM.n42 VGND 0.00654f
C611 VINM.n43 VGND 0.03289f
C612 VINM.n44 VGND 0.0238f
C613 VINM.n45 VGND 0.0445f
C614 VINM.n46 VGND 0.0445f
C615 VINM.n47 VGND 0.0238f
C616 VINM.n48 VGND 0.00954f
C617 VINM.n49 VGND 0.01106f
C618 VINM.t5 VGND 0.17172f
C619 VINM.n50 VGND 0.0233f
C620 VINM.n51 VGND 0.01613f
C621 VINM.n52 VGND 0.13013f
C622 VINM.n53 VGND 0.00654f
C623 VINM.n54 VGND 0.03301f
C624 VINM.n55 VGND 0.0238f
C625 VINM.n56 VGND 0.0448f
C626 VINM.n57 VGND 0.0448f
C627 VINM.n58 VGND 0.0238f
C628 VINM.n59 VGND 0.00954f
C629 VINM.n60 VGND 0.01106f
C630 VINM.t6 VGND 0.17172f
C631 VINM.n61 VGND 0.0233f
C632 VINM.n62 VGND 0.01613f
C633 VINM.n63 VGND 0.13013f
C634 VINM.n64 VGND 0.00654f
C635 VINM.n65 VGND 0.03301f
C636 VINM.n66 VGND 0.0238f
C637 VINM.n67 VGND 0.0448f
C638 VINM.n68 VGND 0.0448f
C639 VINM.n69 VGND 0.0238f
C640 VINM.n70 VGND 0.00954f
C641 VINM.n71 VGND 0.01106f
C642 VINM.t7 VGND 0.17172f
C643 VINM.n72 VGND 0.03289f
C644 VINM.n73 VGND 0.00654f
C645 VINM.n74 VGND 0.13013f
C646 VINM.n75 VGND 0.01614f
C647 VINM.n76 VGND 0.02341f
C648 VINM.n77 VGND 0.0238f
C649 VINM.n78 VGND 0.19005f
C650 D2.t7 VGND 0.02981f
C651 D2.t2 VGND 0.02981f
C652 D2.n0 VGND 0.07723f
C653 D2.n1 VGND 2.04142f
C654 D2.t3 VGND 0.02981f
C655 D2.t1 VGND 0.02981f
C656 D2.n2 VGND 0.07723f
C657 D2.n3 VGND 0.64394f
C658 D2.t6 VGND 0.02981f
C659 D2.t5 VGND 0.02981f
C660 D2.n4 VGND 0.07724f
C661 D2.n5 VGND 0.64455f
C662 D2.t0 VGND 0.02981f
C663 D2.t4 VGND 0.02981f
C664 D2.n6 VGND 0.07692f
C665 D2.n7 VGND 1.00838f
C666 D2.n8 VGND 2.04567f
C667 VBIAS.n0 VGND 0.00256f
C668 VBIAS.n1 VGND 0.00221f
C669 VBIAS.n2 VGND 0.00256f
C670 VBIAS.t10 VGND 0.03979f
C671 VBIAS.t9 VGND 0.00524f
C672 VBIAS.t11 VGND 0.00524f
C673 VBIAS.n3 VGND 0.01075f
C674 VBIAS.n4 VGND 0.00392f
C675 VBIAS.n5 VGND 0.00256f
C676 VBIAS.t8 VGND 0.03979f
C677 VBIAS.n6 VGND 0.00392f
C678 VBIAS.n7 VGND 0.00256f
C679 VBIAS.t6 VGND 0.03979f
C680 VBIAS.t3 VGND 0.00524f
C681 VBIAS.t7 VGND 0.00524f
C682 VBIAS.n8 VGND 0.01075f
C683 VBIAS.n9 VGND 0.00392f
C684 VBIAS.n10 VGND 0.00256f
C685 VBIAS.t2 VGND 0.03979f
C686 VBIAS.n11 VGND 0.00392f
C687 VBIAS.n12 VGND 0.00256f
C688 VBIAS.t0 VGND 0.03979f
C689 VBIAS.t15 VGND 0.00524f
C690 VBIAS.t1 VGND 0.00524f
C691 VBIAS.n13 VGND 0.01075f
C692 VBIAS.n14 VGND 0.00392f
C693 VBIAS.n15 VGND 0.00256f
C694 VBIAS.t14 VGND 0.03979f
C695 VBIAS.n16 VGND 0.00392f
C696 VBIAS.n17 VGND 0.00256f
C697 VBIAS.t12 VGND 0.03979f
C698 VBIAS.t5 VGND 0.00524f
C699 VBIAS.t13 VGND 0.00524f
C700 VBIAS.n18 VGND 0.01075f
C701 VBIAS.t4 VGND 0.06182f
C702 VBIAS.n19 VGND 0.04993f
C703 VBIAS.n20 VGND 0.00406f
C704 VBIAS.n21 VGND 0.00372f
C705 VBIAS.n22 VGND 0.03015f
C706 VBIAS.n23 VGND 0.0015f
C707 VBIAS.n24 VGND 0.00842f
C708 VBIAS.n25 VGND 0.00621f
C709 VBIAS.n26 VGND 0.00372f
C710 VBIAS.n27 VGND 0.03015f
C711 VBIAS.n28 VGND 0.0015f
C712 VBIAS.n29 VGND 0.00636f
C713 VBIAS.n30 VGND 0.0202f
C714 VBIAS.n31 VGND 0.00403f
C715 VBIAS.n32 VGND 0.00372f
C716 VBIAS.n33 VGND 0.03015f
C717 VBIAS.n34 VGND 0.0015f
C718 VBIAS.n35 VGND 0.00842f
C719 VBIAS.n36 VGND 0.00621f
C720 VBIAS.n37 VGND 0.00372f
C721 VBIAS.n38 VGND 0.03015f
C722 VBIAS.n39 VGND 0.0015f
C723 VBIAS.n40 VGND 0.00636f
C724 VBIAS.n41 VGND 0.0202f
C725 VBIAS.n42 VGND 0.00403f
C726 VBIAS.n43 VGND 0.00372f
C727 VBIAS.n44 VGND 0.03015f
C728 VBIAS.n45 VGND 0.0015f
C729 VBIAS.n46 VGND 0.00842f
C730 VBIAS.n47 VGND 0.00621f
C731 VBIAS.n48 VGND 0.00372f
C732 VBIAS.n49 VGND 0.03015f
C733 VBIAS.n50 VGND 0.0015f
C734 VBIAS.n51 VGND 0.0063f
C735 VBIAS.n52 VGND 0.02025f
C736 VBIAS.n53 VGND 0.00596f
C737 VBIAS.n54 VGND 0.0015f
C738 VBIAS.n55 VGND 0.03015f
C739 VBIAS.n56 VGND 0.00374f
C740 VBIAS.n57 VGND 0.00557f
C741 VBIAS.n58 VGND 0.07169f
C742 VBIAS.n59 VGND 0.00256f
C743 VBIAS.n60 VGND 0.00221f
C744 VBIAS.n61 VGND 0.00256f
C745 VBIAS.t23 VGND 0.03979f
C746 VBIAS.n62 VGND 0.00392f
C747 VBIAS.n63 VGND 0.00256f
C748 VBIAS.t22 VGND 0.03979f
C749 VBIAS.n64 VGND 0.00392f
C750 VBIAS.n65 VGND 0.00256f
C751 VBIAS.t21 VGND 0.03979f
C752 VBIAS.n66 VGND 0.00392f
C753 VBIAS.n67 VGND 0.00256f
C754 VBIAS.t20 VGND 0.03979f
C755 VBIAS.n68 VGND 0.00392f
C756 VBIAS.n69 VGND 0.00256f
C757 VBIAS.t19 VGND 0.03979f
C758 VBIAS.n70 VGND 0.00392f
C759 VBIAS.n71 VGND 0.00256f
C760 VBIAS.t18 VGND 0.03979f
C761 VBIAS.n72 VGND 0.00392f
C762 VBIAS.n73 VGND 0.00256f
C763 VBIAS.t17 VGND 0.03979f
C764 VBIAS.t16 VGND 0.06189f
C765 VBIAS.n74 VGND 0.0379f
C766 VBIAS.n75 VGND 0.00372f
C767 VBIAS.n76 VGND 0.03015f
C768 VBIAS.n77 VGND 0.0015f
C769 VBIAS.n78 VGND 0.00842f
C770 VBIAS.n79 VGND 0.00621f
C771 VBIAS.n80 VGND 0.00372f
C772 VBIAS.n81 VGND 0.03015f
C773 VBIAS.n82 VGND 0.0015f
C774 VBIAS.n83 VGND 0.00842f
C775 VBIAS.n84 VGND 0.00621f
C776 VBIAS.n85 VGND 0.00372f
C777 VBIAS.n86 VGND 0.03015f
C778 VBIAS.n87 VGND 0.0015f
C779 VBIAS.n88 VGND 0.00842f
C780 VBIAS.n89 VGND 0.00621f
C781 VBIAS.n90 VGND 0.00372f
C782 VBIAS.n91 VGND 0.03015f
C783 VBIAS.n92 VGND 0.0015f
C784 VBIAS.n93 VGND 0.00842f
C785 VBIAS.n94 VGND 0.00621f
C786 VBIAS.n95 VGND 0.00372f
C787 VBIAS.n96 VGND 0.03015f
C788 VBIAS.n97 VGND 0.0015f
C789 VBIAS.n98 VGND 0.00842f
C790 VBIAS.n99 VGND 0.00621f
C791 VBIAS.n100 VGND 0.00372f
C792 VBIAS.n101 VGND 0.03015f
C793 VBIAS.n102 VGND 0.0015f
C794 VBIAS.n103 VGND 0.00841f
C795 VBIAS.n104 VGND 0.00586f
C796 VBIAS.n105 VGND 0.00372f
C797 VBIAS.n106 VGND 0.03015f
C798 VBIAS.n107 VGND 0.00151f
C799 VBIAS.n108 VGND 0.0078f
C800 VBIAS.n109 VGND 0.02013f
C801 VBIAS.n110 VGND 0.11958f
